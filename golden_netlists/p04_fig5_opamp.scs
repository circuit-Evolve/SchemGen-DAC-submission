// GPDK045 native Cadence adaptation; NOT a performance-matched paper reproduction.
// Missing device sizes/values use recorded defaults; see plan.json and classification CSV.
// Explicit body nets, including deliberately floating bodies, are preserved.
// PDK_BULK_N/PDK_BULK_P, where present, require an external bulk bias.
// Evidence: /projects/2022B4AA1300P/SchematicGeneration/Papers_dataset/consolidated_paper_dataset_final_locked/agnibha_mixed_pdk_20261008/cases/p04_fig5_opamp
// Original comments below describe the pre-conversion topology:
// original: Manually traced from batch1/images/p04_fig5_opamp.png on 2026-10-01.
// original: Topology-only golden netlist; not a Cadence export or simulation deck.
// original: MOS pin order: D G S B. No dimensions, bias values or PDK models supplied.
// original: Grey wires are body connections. M11/M22 bodies go to VDD, not VSS.
// original: M11/M22 have PMOS gate bubbles; their sources are the output nodes.
simulator lang=spectre
global 0
include "/linuxeda_new/c2scadence/FOUNDRY/analog/45nm/models/spectre/gpdk045.scs" section=tt

// AgnibhaMixedPDK_20261008/c42_4e29492904/schematic
M22 (VSS NR VOP VDD) g45p1svt w=(120n) l=45n nf=1 m=(1)
M20 (VOP VB VDD VDD) g45p1svt w=(120n) l=45n nf=1 m=(1)
M11 (VSS NL VOM VDD) g45p1svt w=(120n) l=45n nf=1 m=(1)
M10 (VOM VB VDD VDD) g45p1svt w=(120n) l=45n nf=1 m=(1)
M2 (NR VIM TAIL TAIL) g45p1svt w=(120n) l=45n nf=1 m=(1)
M1 (NL VIP TAIL TAIL) g45p1svt w=(120n) l=45n nf=1 m=(1)
M0 (TAIL VB VDD VDD) g45p1svt w=(120n) l=45n nf=1 m=(1)
M4 (NR VCMFB VSS VSS) g45n1svt w=(120n) l=45n nf=1 m=(1)
M3 (NL VCMFB VSS VSS) g45n1svt w=(120n) l=45n nf=1 m=(1)
