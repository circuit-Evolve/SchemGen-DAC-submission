// GPDK045 native Cadence adaptation; NOT a performance-matched paper reproduction.
// Missing device sizes/values use recorded defaults; see plan.json and classification CSV.
// Explicit body nets, including deliberately floating bodies, are preserved.
// PDK_BULK_N/PDK_BULK_P, where present, require an external bulk bias.
// Evidence: /projects/2022B4AA1300P/SchematicGeneration/Papers_dataset/consolidated_paper_dataset_final_locked/agnibha_mixed_pdk_20261008/cases/p07_fig12_sl_ota
// Original comments below describe the pre-conversion topology:
// original: Image-traced topology reference. All five MOS symbols have D G S only.
// original: Upward/downward filled arrows denote VDD/VSS, not explicit ground symbols.
// original: Orange output-current arrows are annotations, not extra source devices.
simulator lang=spectre
global 0
include "/linuxeda_new/c2scadence/FOUNDRY/analog/45nm/models/spectre/gpdk045.scs" section=tt

// AgnibhaMixedPDK_20261008/c60_bade324426/schematic
M4_R (X_R VBP VDD VDD) g45p1svt w=(120n) l=45n nf=1 m=(1)
M4 (X_L VBP VDD VDD) g45p1svt w=(120n) l=45n nf=1 m=(1)
MTAIL (TAIL VBN VSS VSS) g45n1svt w=(120n) l=45n nf=1 m=(1)
M2_R (X_R B TAIL VSS) g45n1svt w=(120n) l=45n nf=1 m=(1)
M2 (X_L A TAIL VSS) g45n1svt w=(120n) l=45n nf=1 m=(1)
