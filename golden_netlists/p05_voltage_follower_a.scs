// GPDK045 native Cadence adaptation; NOT a performance-matched paper reproduction.
// Missing device sizes/values use recorded defaults; see plan.json and classification CSV.
// Explicit body nets, including deliberately floating bodies, are preserved.
// PDK_BULK_N/PDK_BULK_P, where present, require an external bulk bias.
// Evidence: /projects/2022B4AA1300P/SchematicGeneration/Papers_dataset/consolidated_paper_dataset_final_locked/agnibha_mixed_pdk_20261008/cases/p05_voltage_follower_a
// Original comments below describe the pre-conversion topology:
// original: Image-traced topology reference. All ten MOS symbols have D G S only.
// original: M1/M2 are NMOS; M3/M4 PMOS. All six outer bias devices are retained.
// original: Iref arrow points downward from the PMOS bias diode to the NMOS bias diode.
simulator lang=spectre
global 0
include "/linuxeda_new/c2scadence/FOUNDRY/analog/45nm/models/spectre/gpdk045.scs" section=tt

// AgnibhaMixedPDK_20261008/c52_2348acefa2/schematic
M4 (DOWN_R DOWN_L VOUT VDD) g45p1svt w=(120n) l=45n nf=1 m=(1)
M3 (DOWN_L DOWN_L VIN VDD) g45p1svt w=(120n) l=45n nf=1 m=(1)
PUP_R (UP_R BP VDD VDD) g45p1svt w=(120n) l=45n nf=1 m=(1)
PUP_L (UP_L BP VDD VDD) g45p1svt w=(120n) l=45n nf=1 m=(1)
PBIAS (BP BP VDD VDD) g45p1svt w=(120n) l=45n nf=1 m=(1)
M2 (UP_R UP_L VOUT VSS) g45n1svt w=(120n) l=45n nf=1 m=(1)
M1 (UP_L UP_L VIN VSS) g45n1svt w=(120n) l=45n nf=1 m=(1)
NDOWN_R (DOWN_R BN VSS VSS) g45n1svt w=(120n) l=45n nf=1 m=(1)
NDOWN_L (DOWN_L BN VSS VSS) g45n1svt w=(120n) l=45n nf=1 m=(1)
NBIAS (BN BN VSS VSS) g45n1svt w=(120n) l=45n nf=1 m=(1)
Iref (BP BN) isource dc=0 type=dc
