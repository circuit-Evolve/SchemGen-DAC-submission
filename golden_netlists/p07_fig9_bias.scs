// GPDK045 native Cadence adaptation; NOT a performance-matched paper reproduction.
// Missing device sizes/values use recorded defaults; see plan.json and classification CSV.
// Explicit body nets, including deliberately floating bodies, are preserved.
// PDK_BULK_N/PDK_BULK_P, where present, require an external bulk bias.
// Evidence: /projects/2022B4AA1300P/SchematicGeneration/Papers_dataset/consolidated_paper_dataset_final_locked/agnibha_mixed_pdk_20261008/cases/p07_fig9_bias
// Original comments below describe the pre-conversion topology:
// original: SchemGen Cadence OA topology netlist for GED only
// original: SCHEMGEN_OA_TARGET=GraphReworkLib/gc_fd82e47dfa79_061bbdde/schematic
simulator lang=spectre
global 0
include "/linuxeda_new/c2scadence/FOUNDRY/analog/45nm/models/spectre/gpdk045.scs" section=tt

// AgnibhaMixedPDK_20261008/c62_6bfcd57a01/schematic
dev_nmos_3 (net5 net5 0 0) g45n1svt w=(120n) l=45n nf=1 m=(1)
dev_nmos_2 (net6 net7 0 0) g45n1svt w=(120n) l=45n nf=1 m=(1)
dev_nmos_12 (net3 net5 net4 0) g45n1svt w=(120n) l=45n nf=1 m=(1)
dev_nmos_1 (net4 net3 0 0) g45n1svt w=(120n) l=45n nf=1 m=(1)
dev_nmos_0 (net7 net7 0 0) g45n1svt w=(120n) l=45n nf=1 m=(1)
dev_pmos_8 (net8 net5 net1 PDK_BULK_P) g45p1svt w=(120n) l=45n nf=1 m=(1)
dev_pmos_7 (net2 net5 net1 PDK_BULK_P) g45p1svt w=(120n) l=45n nf=1 m=(1)
dev_pmos_5 (net3 net6 net2 PDK_BULK_P) g45p1svt w=(120n) l=45n nf=1 m=(1)
dev_pmos_11 (net6 net6 net1 PDK_BULK_P) g45p1svt w=(120n) l=45n nf=1 m=(1)
dev_pmos_10 (net5 net6 net8 PDK_BULK_P) g45p1svt w=(120n) l=45n nf=1 m=(1)
