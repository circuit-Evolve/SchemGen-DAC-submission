// GPDK045 native Cadence adaptation; NOT a performance-matched paper reproduction.
// Missing device sizes/values use recorded defaults; see plan.json and classification CSV.
// Explicit body nets, including deliberately floating bodies, are preserved.
// PDK_BULK_N/PDK_BULK_P, where present, require an external bulk bias.
// Evidence: /projects/2022B4AA1300P/SchematicGeneration/Papers_dataset/consolidated_paper_dataset_final_locked/agnibha_mixed_pdk_20261008/cases/p04_fig5_quasi_floating_gate_cdta
// Original comments below describe the pre-conversion topology:
// original: Image-traced topology review: p04_fig5_quasi_floating_gate_cdta.png
// original: Review: batch1_review_all50_20261002; original image and netlist hashes in scope.json.
// original: MOS terminal order: D G S [B]. Explicit body pins follow the image.
// original: Manually repaired topology only; not a native Cadence export or simulation-qualified deck.
// original: Device sizes, model cards, source/passive values and performance are not validated here.
// original: User: both N-labelled nodes are electrically joined, even without a drawn joining wire.
simulator lang=spectre
global 0
include "/linuxeda_new/c2scadence/FOUNDRY/analog/45nm/models/spectre/gpdk045.scs" section=tt

// AgnibhaMixedPDK_20261008/c43_5bdb31033b/schematic
M20 (OUTP MIRROR VDD VDD) g45p1svt w=(120n) l=45n nf=1 m=(1)
M19 (H MIRROR VDD VDD) g45p1svt w=(120n) l=45n nf=1 m=(1)
M18 (MIRROR MIRROR VDD VDD) g45p1svt w=(120n) l=45n nf=1 m=(1)
M17 (G MIRROR VDD VDD) g45p1svt w=(120n) l=45n nf=1 m=(1)
M16 (OUTM MIRROR VDD VDD) g45p1svt w=(120n) l=45n nf=1 m=(1)
M15 (MIRROR MIRROR VDD VDD) g45p1svt w=(120n) l=45n nf=1 m=(1)
M11 (N N C VDD) g45p1svt w=(120n) l=45n nf=1 m=(1)
M10 (C A VDD VDD) g45p1svt w=(120n) l=45n nf=1 m=(1)
M8 (A A VDD VDD) g45p1svt w=(120n) l=45n nf=1 m=(1)
M6 (D FG2 P VDD) g45p1svt w=(120n) l=45n nf=1 m=(1)
M4 (B FG2 N VDD) g45p1svt w=(120n) l=45n nf=1 m=(1)
M2 (NP FG2 0 VDD) g45p1svt w=(120n) l=45n nf=1 m=(1)
M1a (FG1 VDD VDD VDD) g45p1svt w=(120n) l=45n nf=1 m=(1)
IB3 (TAIL VSS) isource dc=0 type=dc
IB2 (NP VSS) isource dc=0 type=dc
IB1 (VDD NB) isource dc=0 type=dc
M24 (OUTP G VSS VSS) g45n1svt w=(120n) l=45n nf=1 m=(1)
M23 (G G VSS VSS) g45n1svt w=(120n) l=45n nf=1 m=(1)
M22 (H H VSS VSS) g45n1svt w=(120n) l=45n nf=1 m=(1)
M21 (OUTM H VSS VSS) g45n1svt w=(120n) l=45n nf=1 m=(1)
M14 (MIRROR 0 TAIL VSS) g45n1svt w=(120n) l=45n nf=1 m=(1)
M13 (MIRROR N TAIL VSS) g45n1svt w=(120n) l=45n nf=1 m=(1)
M12 (N N D VSS) g45n1svt w=(120n) l=45n nf=1 m=(1)
M9 (D B VSS VSS) g45n1svt w=(120n) l=45n nf=1 m=(1)
M7 (B B VSS VSS) g45n1svt w=(120n) l=45n nf=1 m=(1)
M5 (C FG1 P VSS) g45n1svt w=(120n) l=45n nf=1 m=(1)
M3 (A FG1 N VSS) g45n1svt w=(120n) l=45n nf=1 m=(1)
M1 (NB FG1 0 VSS) g45n1svt w=(120n) l=45n nf=1 m=(1)
M2a (FG2 VSS VSS VSS) g45n1svt w=(120n) l=45n nf=1 m=(1)
C2 (NP FG2) capacitor c=1p
C1 (NB FG1) capacitor c=1p
