// GPDK045 native Cadence adaptation; NOT a performance-matched paper reproduction.
// Missing device sizes/values use recorded defaults; see plan.json and classification CSV.
// Explicit body nets, including deliberately floating bodies, are preserved.
// PDK_BULK_N/PDK_BULK_P, where present, require an external bulk bias.
// Evidence: /projects/2022B4AA1300P/SchematicGeneration/Papers_dataset/consolidated_paper_dataset_final_locked/agnibha_mixed_pdk_20261008/cases/p03_recycling_folded_cascode
// Original comments below describe the pre-conversion topology:
// original: SchemGen Cadence OA topology netlist for GED only
// original: SCHEMGEN_OA_TARGET=GraphReworkLib/gc_1194097dbbf5_bc91836f/schematic
simulator lang=spectre
global 0
include "/linuxeda_new/c2scadence/FOUNDRY/analog/45nm/models/spectre/gpdk045.scs" section=tt

// AgnibhaMixedPDK_20261008/c28_6df4a49944/schematic
dev_nmos_cross_1 (net2 net7 net9 0) g45n1svt w=(120n) l=45n nf=1 m=(1)
dev_nmos_cross_0 (net4 net7 net3 0) g45n1svt w=(120n) l=45n nf=1 m=(1)
dev_nmos_8 (net1 net7 net8 0) g45n1svt w=(120n) l=45n nf=1 m=(1)
dev_nmos_5 (net5 net7 net6 0) g45n1svt w=(120n) l=45n nf=1 m=(1)
dev_nmos_4 (net3 net4 0 0) g45n1svt w=(120n) l=45n nf=1 m=(1)
dev_nmos_3 (net9 net2 0 0) g45n1svt w=(120n) l=45n nf=1 m=(1)
dev_nmos_2 (net6 net4 0 0) g45n1svt w=(120n) l=45n nf=1 m=(1)
dev_nmos_11 (net8 net2 0 0) g45n1svt w=(120n) l=45n nf=1 m=(1)
dev_pmos_9 (net13 net1 vdd! vdd!) g45p1svt w=(120n) l=45n nf=1 m=(1)
dev_pmos_7 (net14 net11 vdd! vdd!) g45p1svt w=(120n) l=45n nf=1 m=(1)
dev_pmos_6 (net6 net15 net14 vdd!) g45p1svt w=(120n) l=45n nf=1 m=(1)
dev_pmos_17 (net2 net15 net14 vdd!) g45p1svt w=(120n) l=45n nf=1 m=(1)
dev_pmos_16 (net8 net10 net14 vdd!) g45p1svt w=(120n) l=45n nf=1 m=(1)
dev_pmos_15 (net5 net1 net13 vdd!) g45p1svt w=(120n) l=45n nf=1 m=(1)
dev_pmos_14 (net1 net1 net12 vdd!) g45p1svt w=(120n) l=45n nf=1 m=(1)
dev_pmos_13 (net12 net1 vdd! vdd!) g45p1svt w=(120n) l=45n nf=1 m=(1)
dev_pmos_12 (net11 net11 vdd! vdd!) g45p1svt w=(120n) l=45n nf=1 m=(1)
dev_pmos_10 (net4 net10 net14 vdd!) g45p1svt w=(120n) l=45n nf=1 m=(1)
