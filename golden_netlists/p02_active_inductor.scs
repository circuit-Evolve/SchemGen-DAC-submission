// GPDK045 native Cadence adaptation; NOT a performance-matched paper reproduction.
// Missing device sizes/values use recorded defaults; see plan.json and classification CSV.
// Explicit body nets, including deliberately floating bodies, are preserved.
// PDK_BULK_N/PDK_BULK_P, where present, require an external bulk bias.
// Evidence: /projects/2022B4AA1300P/SchematicGeneration/Papers_dataset/consolidated_paper_dataset_final_locked/agnibha_mixed_pdk_20261008/cases/p02_active_inductor
// Original comments below describe the pre-conversion topology:
// original: SchemGen Cadence OA topology netlist for GED only
// original: SCHEMGEN_OA_TARGET=GraphReworkLib/gc_64599d201a25_5491dbbb/schematic
simulator lang=spectre
global 0
include "/linuxeda_new/c2scadence/FOUNDRY/analog/45nm/models/spectre/gpdk045.scs" section=tt

// AgnibhaMixedPDK_20261008/c02_8225032ba9/schematic
dev_nmos_5 (vdd! net5 net1 0) g45n1svt w=(120n) l=45n nf=1 m=(1)
dev_nmos_4 (net3 net4 net1 0) g45n1svt w=(120n) l=45n nf=1 m=(1)
dev_nmos_3 (net8 net2 net3 0) g45n1svt w=(120n) l=45n nf=1 m=(1)
dev_current_2 (vdd! net3) isource dc=0 type=dc
dev_current_1 (net5 0) isource dc=0 type=dc
dev_current_0 (net1 0) isource dc=0 type=dc
dev_pmos_7 (net6 net8 vdd! vdd!) g45p1svt w=(120n) l=45n nf=1 m=(1)
dev_pmos_6 (net5 net7 net6 vdd!) g45p1svt w=(120n) l=45n nf=1 m=(1)
