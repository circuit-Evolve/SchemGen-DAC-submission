// SchemGen Cadence OA topology netlist for GED only
// SCHEMGEN_OA_TARGET=GraphReworkLib/gc_cc47cfe716db_5c37af87/schematic
I1 ( vdd! net4 ) isource
I2 ( vdd! net5 ) isource
dev_capacitor_4 ( net2 net1 ) capacitor
dev_nmos_0 ( net4 net2 0 ) nmos1v_3
dev_nmos_1 ( net5 net4 0 ) nmos1v_3
dev_resistor2_5 ( net2 net4 ) resistor
