// GPDK045 native Cadence adaptation; NOT a performance-matched paper reproduction.
// Missing device sizes/values use recorded defaults; see plan.json and classification CSV.
// Explicit body nets, including deliberately floating bodies, are preserved.
// PDK_BULK_N/PDK_BULK_P, where present, require an external bulk bias.
// Evidence: /projects/2022B4AA1300P/SchematicGeneration/Papers_dataset/consolidated_paper_dataset_final_locked/agnibha_mixed_pdk_20261008/cases/p02_fig1_linearized_lna
// Original comments below describe the pre-conversion topology:
// original: SchemGen Cadence OA topology netlist for GED only
// original: SCHEMGEN_OA_TARGET=GraphReworkLib/gc_5baa10ba11ba_3f95d1eb/schematic
simulator lang=spectre
global 0
include "/linuxeda_new/c2scadence/FOUNDRY/analog/45nm/models/spectre/gpdk045.scs" section=tt

// AgnibhaMixedPDK_20261008/c07_16cde82e5e/schematic
dev_capacitor_9 (net3 net10) capacitor c=1p
dev_capacitor_8 (net12 net9) capacitor c=1p
dev_capacitor_13 (0 net5) capacitor c=1p
dev_capacitor_11 (net6 net1) capacitor c=1p
dev_capacitor_10 (net7 net6) capacitor c=1p
dev_inductor_25 (net3 vdd!) inductor l=1n
dev_inductor_24 (net4 net2) inductor l=1n
dev_inductor_22 (net1 net12) inductor l=1n
dev_inductor_20 (0 net6) inductor l=1n
dev_nmos_bulk_3 (net4 net1 net6 net7) g45n1svt w=(120n) l=45n nf=1 m=(1)
dev_nmos_bulk_2 (net8 net8 0 0) g45n1svt w=(120n) l=45n nf=1 m=(1)
dev_nmos_bulk_18 (net4 net4 net5 0) g45n1svt w=(120n) l=45n nf=1 m=(1)
dev_nmos_bulk_1 (net3 vdd! net2 0) g45n1svt w=(120n) l=45n nf=1 m=(1)
dev_resistor2_7 (0 net5) resistor r=1K
dev_resistor2_6 (net11 net7) resistor r=1K
dev_resistor2_15 (net8 vdd!) resistor r=1K
dev_resistor2_12 (net12 net8) resistor r=1K
dev_voltage_0 (net11 0) vsource dc=0 type=dc
