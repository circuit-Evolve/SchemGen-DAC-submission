simulator lang=spectre
// Topology-only Spectre netlist generated from canonical JSON.
// Canonical JSON is authoritative. Source record: 10_1051_epjconf_201716201048_03_001.json
current_0_0 ( VDD Vin ) isource
nmos_1_1 ( Vin Vin 0 ) nmos1v_3
nmos_2_2 ( Vout Vin 0 ) nmos1v_3
