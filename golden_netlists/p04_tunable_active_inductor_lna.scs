// GPDK045 native Cadence adaptation; NOT a performance-matched paper reproduction.
// Missing device sizes/values use recorded defaults; see plan.json and classification CSV.
// Explicit body nets, including deliberately floating bodies, are preserved.
// PDK_BULK_N/PDK_BULK_P, where present, require an external bulk bias.
// Evidence: /projects/2022B4AA1300P/SchematicGeneration/Papers_dataset/consolidated_paper_dataset_final_locked/agnibha_mixed_pdk_20261008/cases/p04_tunable_active_inductor_lna
// Original comments below describe the pre-conversion topology:
// original: Image-traced topology review: p04_tunable_active_inductor_lna.png
// original: Review: batch1_review_all50_20261002; original image and netlist hashes in scope.json.
// original: MOS terminal order: D G S [B]. Explicit body pins follow the image.
// original: Manually repaired topology only; not a native Cadence export or simulation-qualified deck.
// original: Device sizes, model cards, source/passive values and performance are not validated here.
simulator lang=spectre
global 0
include "/linuxeda_new/c2scadence/FOUNDRY/analog/45nm/models/spectre/gpdk045.scs" section=tt

// AgnibhaMixedPDK_20261008/c46_355a9e317a/schematic
MOSFET11 (VDD VB1 NR VDD) g45p1svt w=(120n) l=45n nf=1 m=(1)
MOSFET12 (VDD VB1 NL VDD) g45p1svt w=(120n) l=45n nf=1 m=(1)
MOSFET1 (OUT 0 0 0) g45n1svt w=(120n) l=45n nf=1 m=(1)
MOSFET2 (VDD NR OUT 0) g45n1svt w=(120n) l=45n nf=1 m=(1)
MOSFET4 (INPUT VB5 0 0) g45n1svt w=(120n) l=45n nf=1 m=(1)
MOSFET3 (NL VB3 INPUT 0) g45n1svt w=(120n) l=45n nf=1 m=(1)
MOSFET5 (VDD NR NL 0) g45n1svt w=(120n) l=45n nf=1 m=(1)
MOSFET9 (TAIL VB1 0 0) g45n1svt w=(120n) l=45n nf=1 m=(1)
MOSFET13 (TAIL NL NLOW2 0) g45n1svt w=(120n) l=45n nf=1 m=(1)
MOSFET7 (NLOW1 VB3 TAIL 0) g45n1svt w=(120n) l=45n nf=1 m=(1)
MOSFET6 (NR VB2 NLOW2 0) g45n1svt w=(120n) l=45n nf=1 m=(1)
MOSFET8 (NL VB2 NLOW1 0) g45n1svt w=(120n) l=45n nf=1 m=(1)
TERM2 (OUT 0) resistor r=1K
TERM1 (INPUT 0) resistor r=1K
SRC6 (VDD 0) vsource dc=0 type=dc
SRC5 (VB5 0) vsource dc=0 type=dc
SRC3 (VB3 0) vsource dc=0 type=dc
SRC2 (VB2 0) vsource dc=0 type=dc
SRC1 (VB1 0) vsource dc=0 type=dc
