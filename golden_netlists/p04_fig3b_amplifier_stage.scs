// GPDK045 native Cadence adaptation; NOT a performance-matched paper reproduction.
// Missing device sizes/values use recorded defaults; see plan.json and classification CSV.
// Explicit body nets, including deliberately floating bodies, are preserved.
// PDK_BULK_N/PDK_BULK_P, where present, require an external bulk bias.
// Evidence: /projects/2022B4AA1300P/SchematicGeneration/Papers_dataset/consolidated_paper_dataset_final_locked/agnibha_mixed_pdk_20261008/cases/p04_fig3b_amplifier_stage
// Original comments below describe the pre-conversion topology:
// original: SchemGen Cadence OA topology netlist for GED only
// original: SCHEMGEN_OA_TARGET=GraphReworkLib/gc_7af71eb49fa1_ebf945e5/schematic
simulator lang=spectre
global 0
include "/linuxeda_new/c2scadence/FOUNDRY/analog/45nm/models/spectre/gpdk045.scs" section=tt

// AgnibhaMixedPDK_20261008/c36_a9d6aafabe/schematic
dev_nmos_9 (net4 net5 0 0) g45n1svt w=(120n) l=45n nf=1 m=(1)
dev_nmos_8 (net11 net5 0 0) g45n1svt w=(120n) l=45n nf=1 m=(1)
dev_nmos_6 (net1 net12 net10 0) g45n1svt w=(120n) l=45n nf=1 m=(1)
dev_nmos_4 (net9 net8 net11 0) g45n1svt w=(120n) l=45n nf=1 m=(1)
dev_nmos_3 (net3 net8 net4 0) g45n1svt w=(120n) l=45n nf=1 m=(1)
dev_nmos_2 (net1 net2 net9 0) g45n1svt w=(120n) l=45n nf=1 m=(1)
dev_nmos_11 (net10 net8 net7 0) g45n1svt w=(120n) l=45n nf=1 m=(1)
dev_nmos_10 (net13 net6 net10 0) g45n1svt w=(120n) l=45n nf=1 m=(1)
dev_nmos_1 (net13 net16 net9 0) g45n1svt w=(120n) l=45n nf=1 m=(1)
dev_nmos_0 (net7 net5 0 0) g45n1svt w=(120n) l=45n nf=1 m=(1)
dev_pmos_7 (net1 net1 net14 PDK_BULK_P) g45p1svt w=(120n) l=45n nf=1 m=(1)
dev_pmos_5 (net3 net1 net14 PDK_BULK_P) g45p1svt w=(120n) l=45n nf=1 m=(1)
dev_pmos_15 (net1 net1 net14 PDK_BULK_P) g45p1svt w=(120n) l=45n nf=1 m=(1)
dev_pmos_13 (net13 net13 net14 PDK_BULK_P) g45p1svt w=(120n) l=45n nf=1 m=(1)
dev_pmos_12 (net13 net13 net14 PDK_BULK_P) g45p1svt w=(120n) l=45n nf=1 m=(1)
