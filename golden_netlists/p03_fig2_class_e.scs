// GPDK045 native Cadence adaptation; NOT a performance-matched paper reproduction.
// Missing device sizes/values use recorded defaults; see plan.json and classification CSV.
// Explicit body nets, including deliberately floating bodies, are preserved.
// PDK_BULK_N/PDK_BULK_P, where present, require an external bulk bias.
// Evidence: /projects/2022B4AA1300P/SchematicGeneration/Papers_dataset/consolidated_paper_dataset_final_locked/agnibha_mixed_pdk_20261008/cases/p03_fig2_class_e
// Original comments below describe the pre-conversion topology:
// original: SchemGen Cadence OA topology netlist for GED only
// original: SCHEMGEN_OA_TARGET=GraphReworkLib/gc_4584d9a41ba1_12540136/schematic
simulator lang=spectre
global 0
include "/linuxeda_new/c2scadence/FOUNDRY/analog/45nm/models/spectre/gpdk045.scs" section=tt

// AgnibhaMixedPDK_20261008/c19_8d75fbf235/schematic
dev_capacitor_4 (net1 net4) capacitor c=1p
dev_capacitor_2 (net2 net3) capacitor c=1p
dev_capacitor_1 (0 net5) capacitor c=1p
dev_inductor_16 (net6 net5) inductor l=1n
dev_inductor_15 (net2 net1) inductor l=1n
dev_inductor_10 (net1 net9) inductor l=1n
dev_capacitor_18 (net8 0) vsource dc=0 type=dc
dev_capacitor_17 (net9 0) vsource dc=0 type=dc
dev_nmos_bulk_3 (net7 net7 0 0) g45n1svt w=(120n) l=45n nf=1 m=(1)
dev_nmos_bulk_14 (net1 net9 net4 0) g45n1svt w=(120n) l=45n nf=1 m=(1)
dev_nmos_bulk_12 (net4 net7 0 0) g45n1svt w=(120n) l=45n nf=1 m=(1)
dev_resistor2_13 (net6 net7) resistor r=1K
dev_resistor2_0 (net8 net7) resistor r=1K
