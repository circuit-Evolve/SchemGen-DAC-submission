// GPDK045 native Cadence adaptation; NOT a performance-matched paper reproduction.
// Missing device sizes/values use recorded defaults; see plan.json and classification CSV.
// Explicit body nets, including deliberately floating bodies, are preserved.
// PDK_BULK_N/PDK_BULK_P, where present, require an external bulk bias.
// Evidence: /projects/2022B4AA1300P/SchematicGeneration/Papers_dataset/consolidated_paper_dataset_final_locked/agnibha_mixed_pdk_20261008/cases/p06_fig1e_ccii
// Original comments below describe the pre-conversion topology:
// original: Image-traced topology review: p06_fig1e_ccii.png
// original: Review: batch1_review_all50_20261002; original image and netlist hashes in scope.json.
// original: MOS terminal order: D G S [B]. Explicit body pins follow the image.
// original: Manually repaired topology only; not a native Cadence export or simulation-qualified deck.
// original: Device sizes, model cards, source/passive values and performance are not validated here.
simulator lang=spectre
global 0
include "/linuxeda_new/c2scadence/FOUNDRY/analog/45nm/models/spectre/gpdk045.scs" section=tt

// AgnibhaMixedPDK_20261008/c55_62a4e46c66/schematic
M6 (D C X VDD) g45p1svt w=(120n) l=45n nf=1 m=(1)
M5 (C C Y VDD) g45p1svt w=(120n) l=45n nf=1 m=(1)
M4 (Z B VDD VDD) g45p1svt w=(120n) l=45n nf=1 m=(1)
M3 (B B VDD VDD) g45p1svt w=(120n) l=45n nf=1 m=(1)
M2 (A PB VDD VDD) g45p1svt w=(120n) l=45n nf=1 m=(1)
M1 (PB PB VDD VDD) g45p1svt w=(120n) l=45n nf=1 m=(1)
M13 (Z D VSS VSS) g45n1svt w=(120n) l=45n nf=1 m=(1)
M12 (D D VSS VSS) g45n1svt w=(120n) l=45n nf=1 m=(1)
M11 (C VDD VSS VSS) g45n1svt w=(120n) l=45n nf=1 m=(1)
M10 (PB VDD VSS VSS) g45n1svt w=(120n) l=45n nf=1 m=(1)
M9 (VDD VDD VSS VSS) g45n1svt w=(120n) l=45n nf=1 m=(1)
M8 (B A X VSS) g45n1svt w=(120n) l=45n nf=1 m=(1)
M7 (A A Y VSS) g45n1svt w=(120n) l=45n nf=1 m=(1)
