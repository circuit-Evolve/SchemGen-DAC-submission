// GPDK045 native Cadence adaptation; NOT a performance-matched paper reproduction.
// Missing device sizes/values use recorded defaults; see plan.json and classification CSV.
// Explicit body nets, including deliberately floating bodies, are preserved.
// PDK_BULK_N/PDK_BULK_P, where present, require an external bulk bias.
// Evidence: /projects/2022B4AA1300P/SchematicGeneration/Papers_dataset/consolidated_paper_dataset_final_locked/agnibha_mixed_pdk_20261008/cases/p03_fig2_mocccdta
// Original comments below describe the pre-conversion topology:
// original: Image-reviewed topology netlist; not a simulation deck.
// original: Source image: p03_fig2_mocccdta.png
// original: SOURCE_OA_TARGET=GraphReworkLib/gc_be8f024a3e93_123d1613/schematic
// original: Source OA cell is provenance only; its schematic was NOT modified.
// original: Review record: ../../batch1_review_saved17_20261001/review_record.txt
// original: MOS pin order D G S [B]; BJT C B E; current-source PLUS MINUS.
// original: Rebuilt the 33-MOS topology and both current sources. Separated the merged input/current-mirror nodes, restored the M20/M21 branch, three Z outputs and final differential stage. Kept the two diagonal mirror branches separate at their crossing. IB1 is directed from ground to its bias node; IB2 from the final tail to VSS, as the arrows show. No explicit body pins.
simulator lang=spectre
global 0
include "/linuxeda_new/c2scadence/FOUNDRY/analog/45nm/models/spectre/gpdk045.scs" section=tt

// AgnibhaMixedPDK_20261008/c21_c597f4a38a/schematic
M23 (X Z1 TAIL2 VSS) g45n1svt w=(120n) l=45n nf=1 m=(1)
M22 (J 0 TAIL2 VSS) g45n1svt w=(120n) l=45n nf=1 m=(1)
M33 (Z3 H VSS VSS) g45n1svt w=(120n) l=45n nf=1 m=(1)
M32 (Z2 H VSS VSS) g45n1svt w=(120n) l=45n nf=1 m=(1)
M31 (H H VSS VSS) g45n1svt w=(120n) l=45n nf=1 m=(1)
M30 (I G VSS VSS) g45n1svt w=(120n) l=45n nf=1 m=(1)
M20 (D B Q VSS) g45n1svt w=(120n) l=45n nf=1 m=(1)
M6 (D B P VSS) g45n1svt w=(120n) l=45n nf=1 m=(1)
M5 (C B N VSS) g45n1svt w=(120n) l=45n nf=1 m=(1)
M4 (B B 0 VSS) g45n1svt w=(120n) l=45n nf=1 m=(1)
M13 (Z1 G VSS VSS) g45n1svt w=(120n) l=45n nf=1 m=(1)
M12 (G G VSS VSS) g45n1svt w=(120n) l=45n nf=1 m=(1)
M11 (G F VSS VSS) g45n1svt w=(120n) l=45n nf=1 m=(1)
M10 (F F VSS VSS) g45n1svt w=(120n) l=45n nf=1 m=(1)
M9 (E NB VSS VSS) g45n1svt w=(120n) l=45n nf=1 m=(1)
M8 (A NB VSS VSS) g45n1svt w=(120n) l=45n nf=1 m=(1)
M7 (NB NB VSS VSS) g45n1svt w=(120n) l=45n nf=1 m=(1)
IB2 (TAIL2 VSS) isource dc=0 type=dc
IB1 (0 NB) isource dc=0 type=dc
M25 (X J VDD VDD) g45p1svt w=(120n) l=45n nf=1 m=(1)
M24 (J J VDD VDD) g45p1svt w=(120n) l=45n nf=1 m=(1)
M29 (Z3 I VDD VDD) g45p1svt w=(120n) l=45n nf=1 m=(1)
M28 (Z2 I VDD VDD) g45p1svt w=(120n) l=45n nf=1 m=(1)
M27 (I I VDD VDD) g45p1svt w=(120n) l=45n nf=1 m=(1)
M26 (H D VDD VDD) g45p1svt w=(120n) l=45n nf=1 m=(1)
M19 (Z1 D VDD VDD) g45p1svt w=(120n) l=45n nf=1 m=(1)
M18 (D D VDD VDD) g45p1svt w=(120n) l=45n nf=1 m=(1)
M17 (D C VDD VDD) g45p1svt w=(120n) l=45n nf=1 m=(1)
M16 (C C VDD VDD) g45p1svt w=(120n) l=45n nf=1 m=(1)
M15 (B A VDD VDD) g45p1svt w=(120n) l=45n nf=1 m=(1)
M14 (A A VDD VDD) g45p1svt w=(120n) l=45n nf=1 m=(1)
M21 (G E Q VDD) g45p1svt w=(120n) l=45n nf=1 m=(1)
M3 (G E P VDD) g45p1svt w=(120n) l=45n nf=1 m=(1)
M2 (F E N VDD) g45p1svt w=(120n) l=45n nf=1 m=(1)
M1 (E E 0 VDD) g45p1svt w=(120n) l=45n nf=1 m=(1)
