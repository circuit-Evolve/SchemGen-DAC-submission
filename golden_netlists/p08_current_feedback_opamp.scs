// GPDK045 native Cadence adaptation; NOT a performance-matched paper reproduction.
// Missing device sizes/values use recorded defaults; see plan.json and classification CSV.
// Explicit body nets, including deliberately floating bodies, are preserved.
// PDK_BULK_N/PDK_BULK_P, where present, require an external bulk bias.
// Evidence: /projects/2022B4AA1300P/SchematicGeneration/Papers_dataset/consolidated_paper_dataset_final_locked/agnibha_mixed_pdk_20261008/cases/p08_current_feedback_opamp
// Original comments below describe the pre-conversion topology:
// original: Image-traced topology review: p08_current_feedback_opamp.png
// original: Review: batch1_review_all50_20261002; original image and netlist hashes in scope.json.
// original: MOS terminal order: D G S [B]. Explicit body pins follow the image.
// original: Manually repaired topology only; not a native Cadence export or simulation-qualified deck.
// original: Device sizes, model cards, source/passive values and performance are not validated here.
simulator lang=spectre
global 0
include "/linuxeda_new/c2scadence/FOUNDRY/analog/45nm/models/spectre/gpdk045.scs" section=tt

// AgnibhaMixedPDK_20261008/c66_dbfc274a1f/schematic
M25 (W H VSS VSS) g45n1svt w=(120n) l=45n nf=1 m=(1)
M24 (H NB VSS VSS) g45n1svt w=(120n) l=45n nf=1 m=(1)
M23 (G NB VSS VSS) g45n1svt w=(120n) l=45n nf=1 m=(1)
M20 (F E W VSS) g45n1svt w=(120n) l=45n nf=1 m=(1)
M19 (E E Z VSS) g45n1svt w=(120n) l=45n nf=1 m=(1)
M7 (Z D VSS VSS) g45n1svt w=(120n) l=45n nf=1 m=(1)
M6 (X D VSS VSS) g45n1svt w=(120n) l=45n nf=1 m=(1)
M14 (D NB VSS VSS) g45n1svt w=(120n) l=45n nf=1 m=(1)
M11 (C NB VSS VSS) g45n1svt w=(120n) l=45n nf=1 m=(1)
M4 (B A X VSS) g45n1svt w=(120n) l=45n nf=1 m=(1)
M2 (A A Y VSS) g45n1svt w=(120n) l=45n nf=1 m=(1)
M12 (PB NB VSS VSS) g45n1svt w=(120n) l=45n nf=1 m=(1)
M13 (NB NB VSS VSS) g45n1svt w=(120n) l=45n nf=1 m=(1)
Iref (VDD NB) isource dc=0 type=dc
M18 (W F VDD VDD) g45p1svt w=(120n) l=45n nf=1 m=(1)
M21 (H G W VDD) g45p1svt w=(120n) l=45n nf=1 m=(1)
M22 (G G Z VDD) g45p1svt w=(120n) l=45n nf=1 m=(1)
M17 (F PB VDD VDD) g45p1svt w=(120n) l=45n nf=1 m=(1)
M16 (E PB VDD VDD) g45p1svt w=(120n) l=45n nf=1 m=(1)
M15 (Z B VDD VDD) g45p1svt w=(120n) l=45n nf=1 m=(1)
M5 (X B VDD VDD) g45p1svt w=(120n) l=45n nf=1 m=(1)
M3 (D C X VDD) g45p1svt w=(120n) l=45n nf=1 m=(1)
M1 (C C Y VDD) g45p1svt w=(120n) l=45n nf=1 m=(1)
M8 (B PB VDD VDD) g45p1svt w=(120n) l=45n nf=1 m=(1)
M9 (A PB VDD VDD) g45p1svt w=(120n) l=45n nf=1 m=(1)
M10 (PB PB VDD VDD) g45p1svt w=(120n) l=45n nf=1 m=(1)
