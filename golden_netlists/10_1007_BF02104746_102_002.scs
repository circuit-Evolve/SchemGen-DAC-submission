// SchemGen Cadence OA topology netlist for GED only
// SCHEMGEN_OA_TARGET=SchemGenLib_gpdk045/03_missing9_backup_20260924_013131_794743_refined__10_1007_BF02104746_102_002_final__89ec8da963/schematic
VDD_SRC ( VDD 0 ) vsource schemgen_role=synthetic_supply
nmos_3 ( l l 0 ) nmos1v_3
nmos_4 ( k VB4 0 ) nmos1v_3
nmos_5 ( OUT l 0 ) nmos1v_3
nmos_6 ( g IN- k ) nmos1v_3
nmos_7 ( f IN+ k ) nmos1v_3
pmos_10 ( OUT VB2 d ) pmos1v_3
pmos_11 ( c f VDD ) pmos1v_3
pmos_12 ( d g VDD ) pmos1v_3
pmos_8 ( i g VDD ) pmos1v_3
pmos_9 ( b f VDD ) pmos1v_3
pmos_cross_0 ( l VB2 b ) pmos1v_3
pmos_cross_1 ( f VB2 c ) pmos1v_3
pmos_cross_2 ( g VB2 i ) pmos1v_3
