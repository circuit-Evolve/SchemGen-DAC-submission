// GPDK045 native Cadence adaptation; NOT a performance-matched paper reproduction.
// Missing device sizes/values use recorded defaults; see plan.json and classification CSV.
// Explicit body nets, including deliberately floating bodies, are preserved.
// PDK_BULK_N/PDK_BULK_P, where present, require an external bulk bias.
// Evidence: /projects/2022B4AA1300P/SchematicGeneration/Papers_dataset/consolidated_paper_dataset_final_locked/agnibha_mixed_pdk_20261008/cases/p04_fig2_1_balanced_ota
// Original comments below describe the pre-conversion topology:
// original: SchemGen Cadence OA topology netlist for GED only
// original: SCHEMGEN_OA_TARGET=GraphReworkLib/gc_00be2799531d_12536bd4/schematic
simulator lang=spectre
global 0
include "/linuxeda_new/c2scadence/FOUNDRY/analog/45nm/models/spectre/gpdk045.scs" section=tt

// AgnibhaMixedPDK_20261008/c31_f7cdd0000a/schematic
dev_capacitor_14 (0 net6) capacitor c=1p
dev_current_17 (net7 0) vsource dc=0 type=dc
dev_current_16 (net5 0) vsource dc=0 type=dc
dev_capacitor_15 (net1 0) vsource dc=0 type=dc
dev_nmos_bulk_4 (net4 net5 net2 0) g45n1svt w=(120n) l=45n nf=1 m=(1)
dev_nmos_bulk_3 (net8 net8 0 0) g45n1svt w=(120n) l=45n nf=1 m=(1)
dev_nmos_bulk_2 (net3 net7 net2 0) g45n1svt w=(120n) l=45n nf=1 m=(1)
dev_nmos_bulk_0 (net6 net8 0 0) g45n1svt w=(120n) l=45n nf=1 m=(1)
dev_current_13 (net2 0) isource dc=0 type=dc
dev_pmos_bulk_8 (net3 net3 net1 net1) g45p1svt w=(120n) l=45n nf=1 m=(1)
dev_pmos_bulk_6 (net8 net4 net1 net1) g45p1svt w=(120n) l=45n nf=1 m=(1)
dev_pmos_bulk_5 (net4 net4 net1 net1) g45p1svt w=(120n) l=45n nf=1 m=(1)
dev_pmos_bulk_1 (net6 net3 net1 net1) g45p1svt w=(120n) l=45n nf=1 m=(1)
