// SchemGen Cadence OA topology netlist for GED only
// SCHEMGEN_OA_TARGET=GraphReworkLib/gc_345056fddf9f_938885ff/schematic
V1 ( net10 0 ) vsource
dev_capacitor_15 ( 0 net3 ) capacitor
dev_capacitor_16 ( 0 net9 ) capacitor
dev_capacitor_18 ( 0 net7 ) capacitor
dev_current_20 ( net11 net4 ) isource
dev_current_21 ( net2 0 ) isource
dev_inductor_14 ( net7 net6 ) inductor
dev_inductor_17 ( net9 net8 ) inductor
dev_inductor_19 ( net10 net3 ) inductor
dev_nmos_22 ( net11 net1 0 ) nmos1v_3
dev_resistor2_4 ( net2 net3 ) resistor
dev_resistor2_5 ( net7 net4 ) resistor
dev_resistor2_6 ( net9 net5 ) resistor
dev_voltage_0 ( net5 net1 ) vsource
dev_voltage_1 ( net8 0 ) vsource
dev_voltage_3 ( net6 0 ) vsource
