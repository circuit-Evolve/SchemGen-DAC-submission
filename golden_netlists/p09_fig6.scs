// GPDK045 native Cadence adaptation; NOT a performance-matched paper reproduction.
// Missing device sizes/values use recorded defaults; see plan.json and classification CSV.
// Explicit body nets, including deliberately floating bodies, are preserved.
// PDK_BULK_N/PDK_BULK_P, where present, require an external bulk bias.
// Evidence: /projects/2022B4AA1300P/SchematicGeneration/Papers_dataset/consolidated_paper_dataset_final_locked/agnibha_mixed_pdk_20261008/cases/p09_fig6
// Original comments below describe the pre-conversion topology:
// original: Image-traced topology review: p09_fig6.png
// original: Review: batch1_review_all50_20261002; original image and netlist hashes in scope.json.
// original: MOS terminal order: D G S [B]. Explicit body pins follow the image.
// original: Manually repaired topology only; not a native Cadence export or simulation-qualified deck.
// original: Device sizes, model cards, source/passive values and performance are not validated here.
simulator lang=spectre
global 0
include "/linuxeda_new/c2scadence/FOUNDRY/analog/45nm/models/spectre/gpdk045.scs" section=tt

// AgnibhaMixedPDK_20261008/c67_387bdf40f6/schematic
M6 (OUT NR VDD VDD) g45p1svt w=(120n) l=45n nf=1 m=(1)
M4 (NR NL VDD VDD) g45p1svt w=(120n) l=45n nf=1 m=(1)
M3 (NL NL VDD VDD) g45p1svt w=(120n) l=45n nf=1 m=(1)
M9 (NB NB P2 VDD) g45p1svt w=(120n) l=45n nf=1 m=(1)
M10 (P2 P2 P1 VDD) g45p1svt w=(120n) l=45n nf=1 m=(1)
M11 (P1 P1 VDD VDD) g45p1svt w=(120n) l=45n nf=1 m=(1)
M7 (OUT VBIAS VSS VSS) g45n1svt w=(120n) l=45n nf=1 m=(1)
M5 (TAIL VBIAS VSS VSS) g45n1svt w=(120n) l=45n nf=1 m=(1)
M2 (NR VINP TAIL VSS) g45n1svt w=(120n) l=45n nf=1 m=(1)
M1 (NL VINM TAIL VSS) g45n1svt w=(120n) l=45n nf=1 m=(1)
M8 (NB VSS VSS NB) g45n1svt w=(120n) l=45n nf=1 m=(1)
CL (OUT 0) capacitor c=1p
CC (NR OUT) capacitor c=1p
