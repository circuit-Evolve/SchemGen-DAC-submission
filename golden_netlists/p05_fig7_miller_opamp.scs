// GPDK045 native Cadence adaptation; NOT a performance-matched paper reproduction.
// Missing device sizes/values use recorded defaults; see plan.json and classification CSV.
// Explicit body nets, including deliberately floating bodies, are preserved.
// PDK_BULK_N/PDK_BULK_P, where present, require an external bulk bias.
// Evidence: /projects/2022B4AA1300P/SchematicGeneration/Papers_dataset/consolidated_paper_dataset_final_locked/agnibha_mixed_pdk_20261008/cases/p05_fig7_miller_opamp
// Original comments below describe the pre-conversion topology:
// original: Image-traced topology review: p05_fig7_miller_opamp.png
// original: Review: batch1_review_all50_20261002; original image and netlist hashes in scope.json.
// original: MOS terminal order: D G S [B]. Explicit body pins follow the image.
// original: Manually repaired topology only; not a native Cadence export or simulation-qualified deck.
// original: Device sizes, model cards, source/passive values and performance are not validated here.
// original: User: the dotted line joins both Rlarge resistors to VBN; Mtail is NMOS.
simulator lang=spectre
global 0
include "/linuxeda_new/c2scadence/FOUNDRY/analog/45nm/models/spectre/gpdk045.scs" section=tt

// AgnibhaMixedPDK_20261008/c50_c649dbf90c/schematic
MPOUTR (OUTN R VDD VDD) g45p1svt w=(120n) l=45n nf=1 m=(1)
MPOUTL (OUTP L VDD VDD) g45p1svt w=(120n) l=45n nf=1 m=(1)
M1PR (R VCTRL VDD VDD) g45p1svt w=(120n) l=45n nf=1 m=(1)
M1P (L VCTRL VDD VDD) g45p1svt w=(120n) l=45n nf=1 m=(1)
MNOUTR (OUTN XR VSS VSS) g45n1svt w=(120n) l=45n nf=1 m=(1)
MNOUTL (OUTP X VSS VSS) g45n1svt w=(120n) l=45n nf=1 m=(1)
MTAIL (TAIL VBN VSS VSS) g45n1svt w=(120n) l=45n nf=1 m=(1)
MDPR (R VIN TAIL VSS) g45n1svt w=(120n) l=45n nf=1 m=(1)
MDP (L VIP TAIL VSS) g45n1svt w=(120n) l=45n nf=1 m=(1)
CBATR (R XR) capacitor c=1p
CBATL (L X) capacitor c=1p
CCR (OUTN NC2) capacitor c=1p
CCL (OUTP NC1) capacitor c=1p
RLARGER (XR VBN) resistor r=1K
RLARGEL (X VBN) resistor r=1K
RCR (NC2 R) resistor r=1K
RCL (NC1 L) resistor r=1K
