// GPDK045 native Cadence adaptation; NOT a performance-matched paper reproduction.
// Missing device sizes/values use recorded defaults; see plan.json and classification CSV.
// Explicit body nets, including deliberately floating bodies, are preserved.
// PDK_BULK_N/PDK_BULK_P, where present, require an external bulk bias.
// Evidence: /projects/2022B4AA1300P/SchematicGeneration/Papers_dataset/consolidated_paper_dataset_final_locked/agnibha_mixed_pdk_20261008/cases/p02_fig1
// Original comments below describe the pre-conversion topology:
// original: SchemGen Cadence OA topology netlist for GED only
// original: SCHEMGEN_OA_TARGET=GraphReworkLib/gc_86330d4ab73f_989fae5f/schematic
simulator lang=spectre
global 0
include "/linuxeda_new/c2scadence/FOUNDRY/analog/45nm/models/spectre/gpdk045.scs" section=tt

// AgnibhaMixedPDK_20261008/c03_f3f620da27/schematic
dev_capacitor_13 (0 net2) capacitor c=1p
dev_capacitor_12 (0 net6) capacitor c=1p
dev_inductor_8 (net7 net6) inductor l=1n
dev_inductor_2 (net4 net7) inductor l=1n
dev_current_0 (0 net6) isource dc=0 type=dc
dev_nmos_5 (net5 net7 0 0) g45n1svt w=(120n) l=45n nf=1 m=(1)
dev_nmos_14 (net3 net5 net4 0) g45n1svt w=(120n) l=45n nf=1 m=(1)
dev_nmos_11 (net1 net3 net2 0) g45n1svt w=(120n) l=45n nf=1 m=(1)
dev_nmos_10 (vdd! net1 net8 0) g45n1svt w=(120n) l=45n nf=1 m=(1)
dev_resistor2_9 (net5 vdd!) resistor r=1K
dev_resistor2_7 (net3 vdd!) resistor r=1K
dev_resistor2_6 (net1 vdd!) resistor r=1K
dev_resistor2_4 (0 net8) resistor r=1K
dev_resistor2_3 (0 net4) resistor r=1K
dev_resistor2_1 (0 net2) resistor r=1K
