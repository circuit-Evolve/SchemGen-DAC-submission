// GPDK045 native Cadence adaptation; NOT a performance-matched paper reproduction.
// Missing device sizes/values use recorded defaults; see plan.json and classification CSV.
// Explicit body nets, including deliberately floating bodies, are preserved.
// PDK_BULK_N/PDK_BULK_P, where present, require an external bulk bias.
// Evidence: /projects/2022B4AA1300P/SchematicGeneration/Papers_dataset/consolidated_paper_dataset_final_locked/agnibha_mixed_pdk_20261008/cases/p04_fig5a_differential_amplifier
// Original comments below describe the pre-conversion topology:
// original: SchemGen Cadence OA topology netlist for GED only
// original: SCHEMGEN_OA_TARGET=GraphReworkLib/gc_f53b62bea746_065980e0/schematic
simulator lang=spectre
global 0
include "/linuxeda_new/c2scadence/FOUNDRY/analog/45nm/models/spectre/gpdk045.scs" section=tt

// AgnibhaMixedPDK_20261008/c45_f394e5242f/schematic
dev_nmos_2 (net4 net5 net2 PDK_BULK_N) g45n1svt w=(120n) l=45n nf=1 m=(1)
dev_nmos_1 (net2 net7 net8 PDK_BULK_N) g45n1svt w=(120n) l=45n nf=1 m=(1)
dev_nmos_0 (net1 net6 net2 PDK_BULK_N) g45n1svt w=(120n) l=45n nf=1 m=(1)
dev_pmos_4 (net4 net1 net3 PDK_BULK_P) g45p1svt w=(120n) l=45n nf=1 m=(1)
dev_pmos_3 (net1 net1 net3 PDK_BULK_P) g45p1svt w=(120n) l=45n nf=1 m=(1)
