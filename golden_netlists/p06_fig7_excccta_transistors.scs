// GPDK045 native Cadence adaptation; NOT a performance-matched paper reproduction.
// Missing device sizes/values use recorded defaults; see plan.json and classification CSV.
// Explicit body nets, including deliberately floating bodies, are preserved.
// PDK_BULK_N/PDK_BULK_P, where present, require an external bulk bias.
// Evidence: /projects/2022B4AA1300P/SchematicGeneration/Papers_dataset/consolidated_paper_dataset_final_locked/agnibha_mixed_pdk_20261008/cases/p06_fig7_excccta_transistors
// Original comments below describe the pre-conversion topology:
// original: SchemGen Cadence OA topology netlist for GED only
// original: SCHEMGEN_OA_TARGET=GraphReworkLib/gc_f01407c83100_11f4604e/schematic
simulator lang=spectre
global 0
include "/linuxeda_new/c2scadence/FOUNDRY/analog/45nm/models/spectre/gpdk045.scs" section=tt

// AgnibhaMixedPDK_20261008/c58_1a7a6180c6/schematic
dev_nmos_cross_46 (net10 net20 net30 0) g45n1svt w=(120n) l=45n nf=1 m=(1)
dev_nmos_cross_45 (net16 net28 net17 0) g45n1svt w=(120n) l=45n nf=1 m=(1)
dev_nmos_cross_42 (net15 net18 net30 0) g45n1svt w=(120n) l=45n nf=1 m=(1)
dev_nmos_cross_41 (net29 net13 net30 0) g45n1svt w=(120n) l=45n nf=1 m=(1)
dev_nmos_8 (net4 net12 net30 0) g45n1svt w=(120n) l=45n nf=1 m=(1)
dev_nmos_7 (net2 net1 net30 0) g45n1svt w=(120n) l=45n nf=1 m=(1)
dev_nmos_6 (net28 net28 net26 0) g45n1svt w=(120n) l=45n nf=1 m=(1)
dev_nmos_5 (net22 net15 net23 0) g45n1svt w=(120n) l=45n nf=1 m=(1)
dev_nmos_44 (net24 net27 net30 0) g45n1svt w=(120n) l=45n nf=1 m=(1)
dev_nmos_43 (net3 net20 net30 0) g45n1svt w=(120n) l=45n nf=1 m=(1)
dev_nmos_39 (net20 net20 net30 0) g45n1svt w=(120n) l=45n nf=1 m=(1)
dev_nmos_37 (net5 net8 net30 0) g45n1svt w=(120n) l=45n nf=1 m=(1)
dev_nmos_35 (net25 net13 net30 0) g45n1svt w=(120n) l=45n nf=1 m=(1)
dev_nmos_34 (net18 net18 net30 0) g45n1svt w=(120n) l=45n nf=1 m=(1)
dev_nmos_32 (net6 net28 net19 0) g45n1svt w=(120n) l=45n nf=1 m=(1)
dev_nmos_31 (net27 net27 net30 0) g45n1svt w=(120n) l=45n nf=1 m=(1)
dev_nmos_29 (net11 net18 net30 0) g45n1svt w=(120n) l=45n nf=1 m=(1)
dev_nmos_24 (net13 net13 net30 0) g45n1svt w=(120n) l=45n nf=1 m=(1)
dev_nmos_20 (net8 net8 net30 0) g45n1svt w=(120n) l=45n nf=1 m=(1)
dev_nmos_2 (net9 0 net23 0) g45n1svt w=(120n) l=45n nf=1 m=(1)
dev_nmos_13 (net12 net12 net30 0) g45n1svt w=(120n) l=45n nf=1 m=(1)
dev_nmos_10 (net21 net10 net14 0) g45n1svt w=(120n) l=45n nf=1 m=(1)
dev_nmos_1 (net1 net1 net30 0) g45n1svt w=(120n) l=45n nf=1 m=(1)
dev_nmos_0 (net7 0 net14 0) g45n1svt w=(120n) l=45n nf=1 m=(1)
dev_current_33 (0 net13) isource dc=0 type=dc
dev_current_3 (net14 net30) isource dc=0 type=dc
dev_current_14 (net23 net30) isource dc=0 type=dc
dev_pmos_cross_49 (net10 net6 vdd! vdd!) g45p1svt w=(120n) l=45n nf=1 m=(1)
dev_pmos_cross_48 (net18 net25 net17 vdd!) g45p1svt w=(120n) l=45n nf=1 m=(1)
dev_pmos_cross_40 (net15 net16 vdd! vdd!) g45p1svt w=(120n) l=45n nf=1 m=(1)
dev_pmos_9 (net21 net21 vdd! vdd!) g45p1svt w=(120n) l=45n nf=1 m=(1)
dev_pmos_47 (net6 net6 vdd! vdd!) g45p1svt w=(120n) l=45n nf=1 m=(1)
dev_pmos_4 (net22 net22 vdd! vdd!) g45p1svt w=(120n) l=45n nf=1 m=(1)
dev_pmos_38 (net20 net25 net19 vdd!) g45p1svt w=(120n) l=45n nf=1 m=(1)
dev_pmos_36 (net29 net29 vdd! vdd!) g45p1svt w=(120n) l=45n nf=1 m=(1)
dev_pmos_30 (net28 net29 vdd! vdd!) g45p1svt w=(120n) l=45n nf=1 m=(1)
dev_pmos_28 (net27 net7 vdd! vdd!) g45p1svt w=(120n) l=45n nf=1 m=(1)
dev_pmos_27 (net9 net9 vdd! vdd!) g45p1svt w=(120n) l=45n nf=1 m=(1)
dev_pmos_26 (net25 net25 net26 vdd!) g45p1svt w=(120n) l=45n nf=1 m=(1)
dev_pmos_25 (net2 net24 vdd! vdd!) g45p1svt w=(120n) l=45n nf=1 m=(1)
dev_pmos_23 (net8 net9 vdd! vdd!) g45p1svt w=(120n) l=45n nf=1 m=(1)
dev_pmos_22 (net7 net7 vdd! vdd!) g45p1svt w=(120n) l=45n nf=1 m=(1)
dev_pmos_21 (net3 net6 vdd! vdd!) g45p1svt w=(120n) l=45n nf=1 m=(1)
dev_pmos_19 (net1 net21 vdd! vdd!) g45p1svt w=(120n) l=45n nf=1 m=(1)
dev_pmos_18 (net24 net24 vdd! vdd!) g45p1svt w=(120n) l=45n nf=1 m=(1)
dev_pmos_17 (net5 net5 vdd! vdd!) g45p1svt w=(120n) l=45n nf=1 m=(1)
dev_pmos_16 (net11 net16 vdd! vdd!) g45p1svt w=(120n) l=45n nf=1 m=(1)
dev_pmos_15 (net4 net5 vdd! vdd!) g45p1svt w=(120n) l=45n nf=1 m=(1)
dev_pmos_12 (net16 net16 vdd! vdd!) g45p1svt w=(120n) l=45n nf=1 m=(1)
dev_pmos_11 (net12 net22 vdd! vdd!) g45p1svt w=(120n) l=45n nf=1 m=(1)
