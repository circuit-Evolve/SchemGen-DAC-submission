// GPDK045 native Cadence adaptation; NOT a performance-matched paper reproduction.
// Missing device sizes/values use recorded defaults; see plan.json and classification CSV.
// Explicit body nets, including deliberately floating bodies, are preserved.
// PDK_BULK_N/PDK_BULK_P, where present, require an external bulk bias.
// Evidence: /projects/2022B4AA1300P/SchematicGeneration/Papers_dataset/consolidated_paper_dataset_final_locked/agnibha_mixed_pdk_20261008/cases/p02_fig3_gain_enhancement
// Original comments below describe the pre-conversion topology:
// original: Image-reviewed topology netlist; not a simulation deck.
// original: Source image: p02_fig3_gain_enhancement.png
// original: SOURCE_OA_TARGET=GraphReworkLib/gc_e2c39fdc6ce5_34fd255a/schematic
// original: Source OA cell is provenance only; its schematic was NOT modified.
// original: Review record: ../../batch1_review_saved17_20261001/review_record.txt
// original: MOS pin order D G S [B]; BJT C B E; current-source PLUS MINUS.
// original: Added body pins to M3/M4 (VDD) and MA3/MA4 (ground), making all ten MOSFETs four-terminal. Preserved the shared In net confirmed by the user and the crossed enhancement gates.
simulator lang=spectre
global 0
include "/linuxeda_new/c2scadence/FOUNDRY/analog/45nm/models/spectre/gpdk045.scs" section=tt

// AgnibhaMixedPDK_20261008/c12_cc087c0a52/schematic
M6 (BIAS BIAS 0 0) g45n1svt w=(120n) l=45n nf=1 m=(1)
M5 (TAIL BIAS 0 0) g45n1svt w=(120n) l=45n nf=1 m=(1)
MA4 (NB V2 0 0) g45n1svt w=(120n) l=45n nf=1 m=(1)
MA3 (NA V2 0 0) g45n1svt w=(120n) l=45n nf=1 m=(1)
MA2 (OUT NL NB 0) g45n1svt w=(120n) l=45n nf=1 m=(1)
MA1 (NL OUT NA 0) g45n1svt w=(120n) l=45n nf=1 m=(1)
M2 (OUT IN TAIL 0) g45n1svt w=(120n) l=45n nf=1 m=(1)
M1 (NL IN TAIL 0) g45n1svt w=(120n) l=45n nf=1 m=(1)
M4 (OUT NL VDD VDD) g45p1svt w=(120n) l=45n nf=1 m=(1)
M3 (NL NL VDD VDD) g45p1svt w=(120n) l=45n nf=1 m=(1)
C1 (OUT 0) capacitor c=1p
Ibias (VDD BIAS) isource dc=0 type=dc
