// GPDK045 native Cadence adaptation; NOT a performance-matched paper reproduction.
// Missing device sizes/values use recorded defaults; see plan.json and classification CSV.
// Explicit body nets, including deliberately floating bodies, are preserved.
// PDK_BULK_N/PDK_BULK_P, where present, require an external bulk bias.
// Evidence: /projects/2022B4AA1300P/SchematicGeneration/Papers_dataset/consolidated_paper_dataset_final_locked/agnibha_mixed_pdk_20261008/cases/p07_proposed_ota
// Original comments below describe the pre-conversion topology:
// original: Manually traced from batch1/images/p07_proposed_ota.png, 2026-10-01.
// original: Topology-only golden netlist; not a native Cadence export or simulation deck.
// original: MOS pin order D G S B. All 26 body loops connect to their own source.
// original: User confirmed: sideways triangles are ground; input-source upper ends and
// original: the shared VN return remain floating. Undotted crossings are separate.
// original: Repeated R1/C1 and VP/VN value labels do not merge otherwise separate wires.
// original: Voltage-source order is + then -. The sine-wave sources have no marked
// original: polarity; top-to-bottom ordering is a convention, not a simulation claim.
// original: Main differential stage; common-mode feedback drives M4/M5 gates.
// original: Left folded branch: top mirror gates follow NL_BIAS, not VP_L.
// original: Right folded branch: top mirror gates follow NR_BIAS, not VP_R.
// original: Output-average sensing and common-mode stage.
// original: Source symbols retained, including their drawn polarity and open returns.
simulator lang=spectre
global 0
include "/linuxeda_new/c2scadence/FOUNDRY/analog/45nm/models/spectre/gpdk045.scs" section=tt

// AgnibhaMixedPDK_20261008/c65_10d512ebf0/schematic
M24 (CMFB FB_MID CM_TAIL CM_TAIL) g45p1svt w=(120n) l=45n nf=1 m=(1)
M23 (CM_LEFT VCM_PIN CM_TAIL CM_TAIL) g45p1svt w=(120n) l=45n nf=1 m=(1)
M22 (CM_TAIL VDP2 VDD VDD) g45p1svt w=(120n) l=45n nf=1 m=(1)
M19 (VO1 NR_OUTG VDD VDD) g45p1svt w=(120n) l=45n nf=1 m=(1)
M9 (NR_OUTG VP_R PR2 PR2) g45p1svt w=(120n) l=45n nf=1 m=(1)
M8 (NR_BIAS VP_R PR1 PR1) g45p1svt w=(120n) l=45n nf=1 m=(1)
M11 (PR2 NR_BIAS VDD VDD) g45p1svt w=(120n) l=45n nf=1 m=(1)
M10 (PR1 NR_BIAS VDD VDD) g45p1svt w=(120n) l=45n nf=1 m=(1)
M21 (VO2 NL_OUTG VDD VDD) g45p1svt w=(120n) l=45n nf=1 m=(1)
M15 (NL_BIAS VP_L PL2 PL2) g45p1svt w=(120n) l=45n nf=1 m=(1)
M14 (NL_OUTG VP_L PL1 PL1) g45p1svt w=(120n) l=45n nf=1 m=(1)
M17 (PL2 NL_BIAS VDD VDD) g45p1svt w=(120n) l=45n nf=1 m=(1)
M16 (PL1 NL_BIAS VDD VDD) g45p1svt w=(120n) l=45n nf=1 m=(1)
M2 (N2 VIM TAIL TAIL) g45p1svt w=(120n) l=45n nf=1 m=(1)
M1 (N1 VIP TAIL TAIL) g45p1svt w=(120n) l=45n nf=1 m=(1)
M3 (TAIL VDP1 VDD VDD) g45p1svt w=(120n) l=45n nf=1 m=(1)
M26 (CMFB CMFB 0 0) g45n1svt w=(120n) l=45n nf=1 m=(1)
M25 (CM_LEFT CM_LEFT 0 0) g45n1svt w=(120n) l=45n nf=1 m=(1)
M18 (VO1 NR_OUTG 0 0) g45n1svt w=(120n) l=45n nf=1 m=(1)
M7 (NR_OUTG VN_R N2 N2) g45n1svt w=(120n) l=45n nf=1 m=(1)
M6 (NR_BIAS VN_R N1 N1) g45n1svt w=(120n) l=45n nf=1 m=(1)
M20 (VO2 NL_OUTG 0 0) g45n1svt w=(120n) l=45n nf=1 m=(1)
M13 (NL_BIAS VN_L N1 N1) g45n1svt w=(120n) l=45n nf=1 m=(1)
M12 (NL_OUTG VN_L N2 N2) g45n1svt w=(120n) l=45n nf=1 m=(1)
M5 (N2 CMFB 0 0) g45n1svt w=(120n) l=45n nf=1 m=(1)
M4 (N1 CMFB 0 0) g45n1svt w=(120n) l=45n nf=1 m=(1)
C1_RIGHT (VO1 N2) capacitor c=1p
C1_LEFT (VO2 N1) capacitor c=1p
R1_LOWER (FB_MID VO2) resistor r=1K
R1_UPPER (VO1 FB_MID) resistor r=1K
V_INPUT_MINUS (VINM_OPEN VIM) vsource dc=0 type=dc
V_INPUT_PLUS (VINP_OPEN VIP) vsource dc=0 type=dc
V_N_RIGHT (VN_R VN_RETURN_FLOAT) vsource dc=0 type=dc
V_N_LEFT (VN_L VN_RETURN_FLOAT) vsource dc=0 type=dc
V_P_RIGHT (VP_R 0) vsource dc=0 type=dc
V_P_LEFT (VP_L 0) vsource dc=0 type=dc
V_CM (0 VCM_PIN) vsource dc=0 type=dc
V_DP2 (VDP2 0) vsource dc=0 type=dc
V_DP1 (VDP1 0) vsource dc=0 type=dc
V_SUPPLY (VDD 0) vsource dc=0 type=dc
