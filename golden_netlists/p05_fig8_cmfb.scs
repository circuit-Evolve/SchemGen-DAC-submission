// GPDK045 native Cadence adaptation; NOT a performance-matched paper reproduction.
// Missing device sizes/values use recorded defaults; see plan.json and classification CSV.
// Explicit body nets, including deliberately floating bodies, are preserved.
// PDK_BULK_N/PDK_BULK_P, where present, require an external bulk bias.
// Evidence: /projects/2022B4AA1300P/SchematicGeneration/Papers_dataset/consolidated_paper_dataset_final_locked/agnibha_mixed_pdk_20261008/cases/p05_fig8_cmfb
// Original comments below describe the pre-conversion topology:
// original: Image-traced topology reference. All five MOS symbols have D G S only.
// original: All four upward supply arrows are the same VDD rail. Bottom arrow is VSS.
// original: RCM/RPULLUP values are not supplied; retain their symbols/ratios in comments.
// original: R_VON = R_VOP = 2*RCM; R_REF = RCM; both R_PULL_* = RPullUp.
// original: MTAILCM has the image's X2 multiplicity, not two separately wired devices.
simulator lang=spectre
global 0
include "/linuxeda_new/c2scadence/FOUNDRY/analog/45nm/models/spectre/gpdk045.scs" section=tt

// AgnibhaMixedPDK_20261008/c51_381cb8b8e4/schematic
MP_R (RIGHT RIGHT VDD VDD) g45p1svt w=(120n) l=45n nf=1 m=(1)
MP (VCTRLCM VCTRLCM VDD VDD) g45p1svt w=(120n) l=45n nf=1 m=(1)
MTAILCM (TAIL VBN VSS VSS) g45n1svt w=(120n) l=45n nf=1 m=(2)
MN_R (RIGHT REF TAIL VSS) g45n1svt w=(120n) l=45n nf=1 m=(1)
MN (VCTRLCM CM TAIL VSS) g45n1svt w=(120n) l=45n nf=1 m=(1)
R_PULL_R (VDD REF) resistor r=1K
R_PULL_L (VDD CM) resistor r=1K
R_REF (VCMREF REF) resistor r=1K
R_VOP (VOP CM) resistor r=1K
R_VON (VON CM) resistor r=1K
