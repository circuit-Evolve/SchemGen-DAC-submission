// GPDK045 native Cadence adaptation; NOT a performance-matched paper reproduction.
// Missing device sizes/values use recorded defaults; see plan.json and classification CSV.
// Explicit body nets, including deliberately floating bodies, are preserved.
// PDK_BULK_N/PDK_BULK_P, where present, require an external bulk bias.
// Evidence: /projects/2022B4AA1300P/SchematicGeneration/Papers_dataset/consolidated_paper_dataset_final_locked/agnibha_mixed_pdk_20261008/cases/p02_fig2_amplifier
// Original comments below describe the pre-conversion topology:
// original: Manual image-traced topology repair, with user-confirmed connections.
// original: Both MA gates join VIN_COMMON, but neither crossed drain joins that wire.
// original: Both outer M6 sources connect to VDD, as explicitly confirmed by user.
// original: All 15 MOS symbols are three-terminal: D G S. L/R suffixes disambiguate
// original: the duplicated printed names; no extra devices or body pins are invented.
// original: Cross-coupled M2 gates connect to the OPPOSITE M4/M3 drain node.
// original: VIN- and VIN+ in the drawing name this same confirmed VIN_COMMON net.
// original: NB_L, NB_R and PCTRL remain external/open bias nodes as drawn.
simulator lang=spectre
global 0
include "/linuxeda_new/c2scadence/FOUNDRY/analog/45nm/models/spectre/gpdk045.scs" section=tt

// AgnibhaMixedPDK_20261008/c09_0e432300f6/schematic
M5_R (D6_R NB_R 0 0) g45n1svt w=(120n) l=45n nf=1 m=(1)
M5_L (PBIAS NB_L 0 0) g45n1svt w=(120n) l=45n nf=1 m=(1)
M3_R (OP_R NB_R A_R 0) g45n1svt w=(120n) l=45n nf=1 m=(1)
M3_L (OP_L NB_L A_L 0) g45n1svt w=(120n) l=45n nf=1 m=(1)
M2_R (A_R OP_L 0 0) g45n1svt w=(120n) l=45n nf=1 m=(1)
M2_L (A_L OP_R 0 0) g45n1svt w=(120n) l=45n nf=1 m=(1)
M1_R (A_R NB_R 0 0) g45n1svt w=(120n) l=45n nf=1 m=(1)
M1_L (A_L NB_L 0 0) g45n1svt w=(120n) l=45n nf=1 m=(1)
MA_R (A_R VIN_COMMON PTAIL VDD) g45p1svt w=(120n) l=45n nf=1 m=(1)
MA_L (A_L VIN_COMMON PTAIL VDD) g45p1svt w=(120n) l=45n nf=1 m=(1)
MB (PTAIL PCTRL VDD VDD) g45p1svt w=(120n) l=45n nf=1 m=(1)
M6_R (D6_R PBIAS VDD VDD) g45p1svt w=(120n) l=45n nf=1 m=(1)
M6_L (PBIAS PBIAS VDD VDD) g45p1svt w=(120n) l=45n nf=1 m=(1)
M4_R (OP_R PCTRL VDD VDD) g45p1svt w=(120n) l=45n nf=1 m=(1)
M4_L (OP_L PCTRL VDD VDD) g45p1svt w=(120n) l=45n nf=1 m=(1)
