// GPDK045 native Cadence adaptation; NOT a performance-matched paper reproduction.
// Missing device sizes/values use recorded defaults; see plan.json and classification CSV.
// Explicit body nets, including deliberately floating bodies, are preserved.
// PDK_BULK_N/PDK_BULK_P, where present, require an external bulk bias.
// Evidence: /projects/2022B4AA1300P/SchematicGeneration/Papers_dataset/consolidated_paper_dataset_final_locked/agnibha_mixed_pdk_20261008/cases/p02_fig1_differential_amplifier
// Original comments below describe the pre-conversion topology:
// original: SchemGen Cadence OA topology netlist for GED only
// original: SCHEMGEN_OA_TARGET=GraphReworkLib/gc_dc4a134dc9e9_c584328c/schematic
simulator lang=spectre
global 0
include "/linuxeda_new/c2scadence/FOUNDRY/analog/45nm/models/spectre/gpdk045.scs" section=tt

// AgnibhaMixedPDK_20261008/c05_dafc87c42a/schematic
dev_capacitor_17 (net8 net7) capacitor c=1p
dev_nmos_bulk_9 (net1 net1 net4 0) g45n1svt w=(120n) l=45n nf=1 m=(1)
dev_nmos_bulk_8 (net8 net1 net10 0) g45n1svt w=(120n) l=45n nf=1 m=(1)
dev_nmos_bulk_7 (net13 net13 0 0) g45n1svt w=(120n) l=45n nf=1 m=(1)
dev_nmos_bulk_6 (net10 net8 0 0) g45n1svt w=(120n) l=45n nf=1 m=(1)
dev_nmos_bulk_3 (net9 net13 0 0) g45n1svt w=(120n) l=45n nf=1 m=(1)
dev_nmos_bulk_2 (net6 net7 0 0) g45n1svt w=(120n) l=45n nf=1 m=(1)
dev_nmos_bulk_12 (net2 net1 net3 0) g45n1svt w=(120n) l=45n nf=1 m=(1)
dev_nmos_bulk_11 (net7 net1 net6 0) g45n1svt w=(120n) l=45n nf=1 m=(1)
dev_nmos_bulk_1 (net4 net11 0 0) g45n1svt w=(120n) l=45n nf=1 m=(1)
dev_nmos_bulk_0 (net3 net12 0 0) g45n1svt w=(120n) l=45n nf=1 m=(1)
dev_pmos_bulk_5 (net2 net2 net5 net5) g45p1svt w=(120n) l=45n nf=1 m=(1)
dev_pmos_bulk_4 (net7 net2 net5 net5) g45p1svt w=(120n) l=45n nf=1 m=(1)
dev_pmos_bulk_16 (net1 net2 net5 net5) g45p1svt w=(120n) l=45n nf=1 m=(1)
dev_pmos_bulk_15 (net9 net9 net5 net5) g45p1svt w=(120n) l=45n nf=1 m=(1)
dev_pmos_bulk_14 (net8 net2 net5 net5) g45p1svt w=(120n) l=45n nf=1 m=(1)
dev_pmos_bulk_10 (net4 net9 net5 net5) g45p1svt w=(120n) l=45n nf=1 m=(1)
dev_resistor2_13 (net13 net5) resistor r=1K
