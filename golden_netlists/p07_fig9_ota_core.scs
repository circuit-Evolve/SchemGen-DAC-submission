// GPDK045 native Cadence adaptation; NOT a performance-matched paper reproduction.
// Missing device sizes/values use recorded defaults; see plan.json and classification CSV.
// Explicit body nets, including deliberately floating bodies, are preserved.
// PDK_BULK_N/PDK_BULK_P, where present, require an external bulk bias.
// Evidence: /projects/2022B4AA1300P/SchematicGeneration/Papers_dataset/consolidated_paper_dataset_final_locked/agnibha_mixed_pdk_20261008/cases/p07_fig9_ota_core
// Original comments below describe the pre-conversion topology:
// original: SchemGen Cadence OA topology netlist for GED only
// original: SCHEMGEN_OA_TARGET=GraphReworkLib/gc_31fab48a65c7_1d48544a/schematic
simulator lang=spectre
global 0
include "/linuxeda_new/c2scadence/FOUNDRY/analog/45nm/models/spectre/gpdk045.scs" section=tt

// AgnibhaMixedPDK_20261008/c64_49569fdc51/schematic
dev_capacitor_5 (net1 net13) capacitor c=1p
dev_capacitor_4 (net15 net6) capacitor c=1p
dev_capacitor_1 (net15 net10) capacitor c=1p
dev_capacitor_0 (net13 net12) capacitor c=1p
dev_nmos_8 (net13 net11 0 0) g45n1svt w=(120n) l=45n nf=1 m=(1)
dev_nmos_15 (net14 net8 net1 0) g45n1svt w=(120n) l=45n nf=1 m=(1)
dev_nmos_14 (net1 net9 0 0) g45n1svt w=(120n) l=45n nf=1 m=(1)
dev_nmos_12 (net15 net11 0 0) g45n1svt w=(120n) l=45n nf=1 m=(1)
dev_nmos_11 (net6 net9 0 0) g45n1svt w=(120n) l=45n nf=1 m=(1)
dev_nmos_10 (net7 net8 net6 0) g45n1svt w=(120n) l=45n nf=1 m=(1)
dev_pmos_9 (net13 net14 net2 PDK_BULK_P) g45p1svt w=(120n) l=45n nf=1 m=(1)
dev_pmos_7 (net10 net5 net2 PDK_BULK_P) g45p1svt w=(120n) l=45n nf=1 m=(1)
dev_pmos_6 (net12 net5 net2 PDK_BULK_P) g45p1svt w=(120n) l=45n nf=1 m=(1)
dev_pmos_3 (net7 net3 net10 PDK_BULK_P) g45p1svt w=(120n) l=45n nf=1 m=(1)
dev_pmos_22 (net6 net4 net16 PDK_BULK_P) g45p1svt w=(120n) l=45n nf=1 m=(1)
dev_pmos_21 (net16 net5 net2 PDK_BULK_P) g45p1svt w=(120n) l=45n nf=1 m=(1)
dev_pmos_2 (net14 net3 net12 PDK_BULK_P) g45p1svt w=(120n) l=45n nf=1 m=(1)
dev_pmos_17 (net15 net7 net2 PDK_BULK_P) g45p1svt w=(120n) l=45n nf=1 m=(1)
dev_pmos_13 (net1 net17 net16 PDK_BULK_P) g45p1svt w=(120n) l=45n nf=1 m=(1)
