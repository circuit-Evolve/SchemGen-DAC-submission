// GPDK045 native Cadence adaptation; NOT a performance-matched paper reproduction.
// Missing device sizes/values use recorded defaults; see plan.json and classification CSV.
// Explicit body nets, including deliberately floating bodies, are preserved.
// PDK_BULK_N/PDK_BULK_P, where present, require an external bulk bias.
// Evidence: /projects/2022B4AA1300P/SchematicGeneration/Papers_dataset/consolidated_paper_dataset_final_locked/agnibha_mixed_pdk_20261008/cases/p07_fig3_filter_opamp
// Original comments below describe the pre-conversion topology:
// original: SchemGen Cadence OA topology netlist for GED only
// original: SCHEMGEN_OA_TARGET=GraphReworkLib/gc_cb19b9a7694f_250a9c02/schematic
simulator lang=spectre
global 0
include "/linuxeda_new/c2scadence/FOUNDRY/analog/45nm/models/spectre/gpdk045.scs" section=tt

// AgnibhaMixedPDK_20261008/c61_ff137e38e2/schematic
dev_capacitor_23 (net15 net10) capacitor c=1p
dev_capacitor_21 (net15 net14) capacitor c=1p
dev_nmos_7 (net16 net10 0 0) g45n1svt w=(120n) l=45n nf=1 m=(1)
dev_nmos_6 (net5 net4 net1 0) g45n1svt w=(120n) l=45n nf=1 m=(1)
dev_nmos_5 (net10 net4 net3 0) g45n1svt w=(120n) l=45n nf=1 m=(1)
dev_nmos_4 (net3 net2 0 0) g45n1svt w=(120n) l=45n nf=1 m=(1)
dev_nmos_2 (net1 net2 0 0) g45n1svt w=(120n) l=45n nf=1 m=(1)
dev_nmos_13 (net14 net13 net10 0) g45n1svt w=(120n) l=45n nf=1 m=(1)
dev_nmos_1 (net7 net13 net5 0) g45n1svt w=(120n) l=45n nf=1 m=(1)
dev_pmos_9 (net11 net7 vdd! vdd!) g45p1svt w=(120n) l=45n nf=1 m=(1)
dev_pmos_8 (net10 net12 net14 vdd!) g45p1svt w=(120n) l=45n nf=1 m=(1)
dev_pmos_20 (net5 net12 net7 vdd!) g45p1svt w=(120n) l=45n nf=1 m=(1)
dev_pmos_18 (net16 net14 vdd! vdd!) g45p1svt w=(120n) l=45n nf=1 m=(1)
dev_pmos_17 (net17 net9 net19 vdd!) g45p1svt w=(120n) l=45n nf=1 m=(1)
dev_pmos_16 (net14 net9 net11 vdd!) g45p1svt w=(120n) l=45n nf=1 m=(1)
dev_pmos_15 (net8 net7 vdd! vdd!) g45p1svt w=(120n) l=45n nf=1 m=(1)
dev_pmos_14 (net7 net9 net8 vdd!) g45p1svt w=(120n) l=45n nf=1 m=(1)
dev_pmos_12 (net1 net6 net17 vdd!) g45p1svt w=(120n) l=45n nf=1 m=(1)
dev_pmos_11 (net19 net20 vdd! vdd!) g45p1svt w=(120n) l=45n nf=1 m=(1)
dev_pmos_10 (net3 net18 net17 vdd!) g45p1svt w=(120n) l=45n nf=1 m=(1)
dev_resistor2_0 (net16 net15) resistor r=1K
