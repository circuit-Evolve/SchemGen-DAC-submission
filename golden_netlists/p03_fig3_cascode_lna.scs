// GPDK045 native Cadence adaptation; NOT a performance-matched paper reproduction.
// Missing device sizes/values use recorded defaults; see plan.json and classification CSV.
// Explicit body nets, including deliberately floating bodies, are preserved.
// PDK_BULK_N/PDK_BULK_P, where present, require an external bulk bias.
// Evidence: /projects/2022B4AA1300P/SchematicGeneration/Papers_dataset/consolidated_paper_dataset_final_locked/agnibha_mixed_pdk_20261008/cases/p03_fig3_cascode_lna
// Original comments below describe the pre-conversion topology:
// original: SchemGen Cadence OA topology netlist for GED only
// original: SCHEMGEN_OA_TARGET=GraphReworkLib/gc_215ff77dcad6_ac1af664/schematic
simulator lang=spectre
global 0
include "/linuxeda_new/c2scadence/FOUNDRY/analog/45nm/models/spectre/gpdk045.scs" section=tt

// AgnibhaMixedPDK_20261008/c23_3486b02cb0/schematic
dev_gnd_13 (net6 0) capacitor c=1p
dev_capacitor_cb (net5 net8) capacitor c=1p
dev_inductor_8 (net6 vdd!) inductor l=1n
dev_inductor_10 (0 net3) inductor l=1n
dev_inductor_1 (net4 net5) inductor l=1n
dev_nmos_3 (net6 vdd! net2 0) g45n1svt w=(120n) l=45n nf=1 m=(1)
dev_nmos_2 (net2 net4 net3 0) g45n1svt w=(120n) l=45n nf=1 m=(1)
dev_nmos_0 (net1 net1 0 0) g45n1svt w=(120n) l=45n nf=1 m=(1)
dev_resistor2_rs (net8 net7) resistor r=1K
dev_resistor2_7 (net1 vdd!) resistor r=1K
dev_resistor2_6 (net5 net1) resistor r=1K
