// GPDK045 native Cadence adaptation; NOT a performance-matched paper reproduction.
// Missing device sizes/values use recorded defaults; see plan.json and classification CSV.
// Explicit body nets, including deliberately floating bodies, are preserved.
// PDK_BULK_N/PDK_BULK_P, where present, require an external bulk bias.
// Evidence: /projects/2022B4AA1300P/SchematicGeneration/Papers_dataset/consolidated_paper_dataset_final_locked/agnibha_mixed_pdk_20261008/cases/p04_fig3_vd_diba
// Original comments below describe the pre-conversion topology:
// original: Image-traced topology review: p04_fig3_vd_diba.png
// original: Review: batch1_review_all50_20261002; original image and netlist hashes in scope.json.
// original: MOS terminal order: D G S [B]. Explicit body pins follow the image.
// original: Manually repaired topology only; not a native Cadence export or simulation-qualified deck.
// original: Device sizes, model cards, source/passive values and performance are not validated here.
simulator lang=spectre
global 0
include "/linuxeda_new/c2scadence/FOUNDRY/analog/45nm/models/spectre/gpdk045.scs" section=tt

// AgnibhaMixedPDK_20261008/c35_785a49990b/schematic
M20 (VSS NG W VDD) g45p1svt w=(120n) l=45n nf=1 m=(1)
M19 (NG NG U VDD) g45p1svt w=(120n) l=45n nf=1 m=(1)
M24 (PG BIASP PU VDD) g45p1svt w=(120n) l=45n nf=1 m=(1)
M23 (PU PB VDD VDD) g45p1svt w=(120n) l=45n nf=1 m=(1)
M21 (BIASP BIASP PB VDD) g45p1svt w=(120n) l=45n nf=1 m=(1)
M22 (PB PB VDD VDD) g45p1svt w=(120n) l=45n nf=1 m=(1)
M11 (U U TP3 VDD) g45p1svt w=(120n) l=45n nf=1 m=(1)
M12 (0 0 TP3 VDD) g45p1svt w=(120n) l=45n nf=1 m=(1)
M7 (0 V TP2 VDD) g45p1svt w=(120n) l=45n nf=1 m=(1)
M8 (U Z TP2 VDD) g45p1svt w=(120n) l=45n nf=1 m=(1)
M3 (Z VN TP1 VDD) g45p1svt w=(120n) l=45n nf=1 m=(1)
M4 (0 VP TP1 VDD) g45p1svt w=(120n) l=45n nf=1 m=(1)
M18 (VDD PG W VSS) g45n1svt w=(120n) l=45n nf=1 m=(1)
M15 (NG BIASN ND VSS) g45n1svt w=(120n) l=45n nf=1 m=(1)
M16 (ND NB VSS VSS) g45n1svt w=(120n) l=45n nf=1 m=(1)
M14 (BIASN BIASN NB VSS) g45n1svt w=(120n) l=45n nf=1 m=(1)
M13 (NB NB VSS VSS) g45n1svt w=(120n) l=45n nf=1 m=(1)
M17 (PG PG U VSS) g45n1svt w=(120n) l=45n nf=1 m=(1)
M10 (U U TN3 VSS) g45n1svt w=(120n) l=45n nf=1 m=(1)
M9 (0 0 TN3 VSS) g45n1svt w=(120n) l=45n nf=1 m=(1)
M6 (0 V TN2 VSS) g45n1svt w=(120n) l=45n nf=1 m=(1)
M5 (U Z TN2 VSS) g45n1svt w=(120n) l=45n nf=1 m=(1)
M2 (Z VN TN1 VSS) g45n1svt w=(120n) l=45n nf=1 m=(1)
M1 (0 VP TN1 VSS) g45n1svt w=(120n) l=45n nf=1 m=(1)
IB7 (BIASP BIASN) isource dc=0 type=dc
IB6 (TN3 VSS) isource dc=0 type=dc
IB5 (VDD TP3) isource dc=0 type=dc
IB4 (TN2 VSS) isource dc=0 type=dc
IB3 (VDD TP2) isource dc=0 type=dc
IB2 (TN1 VSS) isource dc=0 type=dc
IB1 (VDD TP1) isource dc=0 type=dc
