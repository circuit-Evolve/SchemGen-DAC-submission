// GPDK045 native Cadence adaptation; NOT a performance-matched paper reproduction.
// Missing device sizes/values use recorded defaults; see plan.json and classification CSV.
// Explicit body nets, including deliberately floating bodies, are preserved.
// PDK_BULK_N/PDK_BULK_P, where present, require an external bulk bias.
// Evidence: /projects/2022B4AA1300P/SchematicGeneration/Papers_dataset/consolidated_paper_dataset_final_locked/agnibha_mixed_pdk_20261008/cases/p04_bandgap_reference
// Original comments below describe the pre-conversion topology:
// original: SchemGen Cadence OA topology netlist for GED only
// original: SCHEMGEN_OA_TARGET=GraphReworkLib/gc_5733d2ebc03a_ddbc0366/schematic
simulator lang=spectre
global 0
include "/linuxeda_new/c2scadence/FOUNDRY/analog/45nm/models/spectre/gpdk045.scs" section=tt

// AgnibhaMixedPDK_20261008/c30_e8f70b9d80/schematic
dev_nmos_bulk_4 (net12 net12 net10 0) g45n1svt w=(120n) l=45n nf=1 m=(1)
dev_nmos_bulk_15 (net15 net12 net11 0) g45n1svt w=(120n) l=45n nf=1 m=(1)
dev_current_11 (net7 0) isource dc=0 type=dc
dev_npn_9 (net6 net6 0 ) g45vnpn10 area=100.0 m=1
dev_npn_3 (net10 net10 0 ) g45vnpn10 area=100.0 m=1
dev_npn_14 (net5 net5 0 ) g45vnpn10 area=100.0 m=1
dev_npn_10 (net5 net5 0 ) g45vnpn10 area=100.0 m=1
dev_pmos_bulk_8 (net9 net7 net14 net13) g45p1svt w=(120n) l=45n nf=1 m=(1)
dev_pmos_bulk_7 (net12 net7 net3 vdd!) g45p1svt w=(120n) l=45n nf=1 m=(1)
dev_pmos_bulk_5 (net7 net7 net8 vdd!) g45p1svt w=(120n) l=45n nf=1 m=(1)
dev_pmos_bulk_18 (net15 net7 net1 net4) g45p1svt w=(120n) l=45n nf=1 m=(1)
dev_pmos_bulk_16 (net14 net1 vdd! net13) g45p1svt w=(120n) l=45n nf=1 m=(1)
dev_pmos_bulk_13 (net3 net1 vdd! net2) g45p1svt w=(120n) l=45n nf=1 m=(1)
dev_pmos_bulk_12 (net1 net1 vdd! net4) g45p1svt w=(120n) l=45n nf=1 m=(1)
dev_resistor2_2 (net6 net9) resistor r=1K
dev_resistor2_1 (net5 net11) resistor r=1K
dev_resistor2_0 (net8 vdd!) resistor r=1K
