// GPDK045 native Cadence adaptation; NOT a performance-matched paper reproduction.
// Missing device sizes/values use recorded defaults; see plan.json and classification CSV.
// Explicit body nets, including deliberately floating bodies, are preserved.
// PDK_BULK_N/PDK_BULK_P, where present, require an external bulk bias.
// Evidence: /projects/2022B4AA1300P/SchematicGeneration/Papers_dataset/consolidated_paper_dataset_final_locked/agnibha_mixed_pdk_20261008/cases/p05_fig2c
// Original comments below describe the pre-conversion topology:
// Adaptation: User requested GPDK045 also for the LTPO reference; this is a CMOS topology adaptation, not an LTPO model.
// Adaptation: All original terminal nets are preserved. M12/M13 gates remain joined on INV_GATE_FLOAT and are not connected to NOUT.
// Adaptation: M7/M8 explicit body connections remain VDD. No bias wiring or source voltages were added.
// Adaptation: Missing sizes use W=120 nm, L=45 nm, m=1; CL=1 pF is a documented placeholder.
// Adaptation: The original TFT process, voltage ratings and performance are not reproduced or validated.
// original: Image-traced topology review: p05_fig2c.png
// original: Review: batch1_review_all50_20261002; original image and netlist hashes in scope.json.
// original: MOS terminal order: D G S [B]. Explicit body pins follow the image.
// original: Manually repaired topology only; not a native Cadence export or simulation-qualified deck.
// original: Device sizes, model cards, source/passive values and performance are not validated here.
simulator lang=spectre
global 0
include "/linuxeda_new/c2scadence/FOUNDRY/analog/45nm/models/spectre/gpdk045.scs" section=tt

// AgnibhaMixedPDK_20261008/c70_1a57c79c9d/schematic
M12 (OUT INV_GATE_FLOAT VDD VDD) g45p1svt w=(120n) l=45n nf=1 m=(1)
M10 (NOUT NR VDD VDD) g45p1svt w=(120n) l=45n nf=1 m=(1)
M6 (NR NL VDD VDD) g45p1svt w=(120n) l=45n nf=1 m=(1)
M5 (NL NL VDD VDD) g45p1svt w=(120n) l=45n nf=1 m=(1)
M3 (NB2 NL VDD VDD) g45p1svt w=(120n) l=45n nf=1 m=(1)
M1 (NB NB VDD VDD) g45p1svt w=(120n) l=45n nf=1 m=(1)
M13 (OUT INV_GATE_FLOAT VSS VSS) g45n1svt w=(120n) l=45n nf=1 m=(1)
M11 (NOUT NB2 VSS VSS) g45n1svt w=(120n) l=45n nf=1 m=(1)
M9 (TAIL NB VSS VSS) g45n1svt w=(120n) l=45n nf=1 m=(1)
M8 (NR VIM TAIL VDD) g45n1svt w=(120n) l=45n nf=1 m=(1)
M7 (NL VIP TAIL VDD) g45n1svt w=(120n) l=45n nf=1 m=(1)
M4 (NB2 NB2 VSS VSS) g45n1svt w=(120n) l=45n nf=1 m=(1)
M2 (NB NB VSS VSS) g45n1svt w=(120n) l=45n nf=1 m=(1)
CL (OUT 0) capacitor c=1p
