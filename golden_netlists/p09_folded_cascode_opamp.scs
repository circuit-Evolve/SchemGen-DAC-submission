// GPDK045 native Cadence adaptation; NOT a performance-matched paper reproduction.
// Missing device sizes/values use recorded defaults; see plan.json and classification CSV.
// Explicit body nets, including deliberately floating bodies, are preserved.
// PDK_BULK_N/PDK_BULK_P, where present, require an external bulk bias.
// Evidence: /projects/2022B4AA1300P/SchematicGeneration/Papers_dataset/consolidated_paper_dataset_final_locked/agnibha_mixed_pdk_20261008/cases/p09_folded_cascode_opamp
// Original comments below describe the pre-conversion topology:
// original: Image-traced topology review: p09_folded_cascode_opamp.png
// original: Review: batch1_review_all50_20261002; original image and netlist hashes in scope.json.
// original: MOS terminal order: D G S [B]. Explicit body pins follow the image.
// original: Manually repaired topology only; not a native Cadence export or simulation-qualified deck.
// original: Device sizes, model cards, source/passive values and performance are not validated here.
simulator lang=spectre
global 0
include "/linuxeda_new/c2scadence/FOUNDRY/analog/45nm/models/spectre/gpdk045.scs" section=tt

// AgnibhaMixedPDK_20261008/c68_bc8b4bb8b9/schematic
MF12 (OUT VPT VDD VDD) g45p1svt w=(120n) l=45n nf=1 m=(1)
MF7 (CR VBP PR VDD) g45p1svt w=(120n) l=45n nf=1 m=(1)
MF6 (CL VBP PL VDD) g45p1svt w=(120n) l=45n nf=1 m=(1)
MF5 (PR VPT VDD VDD) g45p1svt w=(120n) l=45n nf=1 m=(1)
MF4 (PL VPT VDD VDD) g45p1svt w=(120n) l=45n nf=1 m=(1)
MF3 (NL VN TAIL VDD) g45p1svt w=(120n) l=45n nf=1 m=(1)
MF2 (NR VP TAIL VDD) g45p1svt w=(120n) l=45n nf=1 m=(1)
MF1 (TAIL VPT VDD VDD) g45p1svt w=(120n) l=45n nf=1 m=(1)
MF13 (OUT CR VSS VSS) g45n1svt w=(120n) l=45n nf=1 m=(1)
MF11 (NR CL VSS VSS) g45n1svt w=(120n) l=45n nf=1 m=(1)
MF10 (NL CL VSS VSS) g45n1svt w=(120n) l=45n nf=1 m=(1)
MF9 (CR VBN NR VSS) g45n1svt w=(120n) l=45n nf=1 m=(1)
MF8 (CL VBN NL VSS) g45n1svt w=(120n) l=45n nf=1 m=(1)
RC (CR NC) resistor r=1K
CC (NC OUT) capacitor c=1p
