// GPDK045 native Cadence adaptation; NOT a performance-matched paper reproduction.
// Missing device sizes/values use recorded defaults; see plan.json and classification CSV.
// Explicit body nets, including deliberately floating bodies, are preserved.
// PDK_BULK_N/PDK_BULK_P, where present, require an external bulk bias.
// Evidence: /projects/2022B4AA1300P/SchematicGeneration/Papers_dataset/consolidated_paper_dataset_final_locked/agnibha_mixed_pdk_20261008/cases/p03_realized_lna
// Original comments below describe the pre-conversion topology:
// original: SchemGen Cadence OA topology netlist for GED only
// original: SCHEMGEN_OA_TARGET=GraphReworkLib/gc_05633f2997cb_7a2a4af1/schematic
simulator lang=spectre
global 0
include "/linuxeda_new/c2scadence/FOUNDRY/analog/45nm/models/spectre/gpdk045.scs" section=tt

// AgnibhaMixedPDK_20261008/c27_baa1a6bc64/schematic
dev_capacitor_9 (net5 net8) capacitor c=1p
dev_capacitor_11 (vdd! net3) capacitor c=1p
dev_capacitor_10 (net3 net2) capacitor c=1p
dev_inductor_5 (net3 vdd!) inductor l=1n
dev_inductor_3 (0 net6) inductor l=1n
dev_inductor_12 (net5 net4) inductor l=1n
dev_nmos_4 (vdd! net2 net1 0) g45n1svt w=(120n) l=45n nf=1 m=(1)
dev_nmos_2 (net3 vdd! net7 0) g45n1svt w=(120n) l=45n nf=1 m=(1)
dev_nmos_1 (net9 net9 0 0) g45n1svt w=(120n) l=45n nf=1 m=(1)
dev_nmos_0 (net7 net8 net6 0) g45n1svt w=(120n) l=45n nf=1 m=(1)
dev_resistor2_8 (net9 vdd!) resistor r=1K
dev_resistor2_7 (0 net1) resistor r=1K
dev_resistor2_6 (net8 net9) resistor r=1K
