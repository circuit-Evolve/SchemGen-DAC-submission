// GPDK045 native Cadence adaptation; NOT a performance-matched paper reproduction.
// Missing device sizes/values use recorded defaults; see plan.json and classification CSV.
// Explicit body nets, including deliberately floating bodies, are preserved.
// PDK_BULK_N/PDK_BULK_P, where present, require an external bulk bias.
// Evidence: /projects/2022B4AA1300P/SchematicGeneration/Papers_dataset/consolidated_paper_dataset_final_locked/agnibha_mixed_pdk_20261008/cases/p02_folded_cascode
// Original comments below describe the pre-conversion topology:
// original: SchemGen Cadence OA topology netlist for GED only
// original: SCHEMGEN_OA_TARGET=GraphReworkLib/gc_78cabf216301_93f2085e/schematic
simulator lang=spectre
global 0
include "/linuxeda_new/c2scadence/FOUNDRY/analog/45nm/models/spectre/gpdk045.scs" section=tt

// AgnibhaMixedPDK_20261008/c14_cb3e178e58/schematic
dev_nmos_7 (net8 net9 0 0) g45n1svt w=(120n) l=45n nf=1 m=(1)
dev_nmos_4 (net4 net3 net8 0) g45n1svt w=(120n) l=45n nf=1 m=(1)
dev_nmos_2 (net6 net3 net11 0) g45n1svt w=(120n) l=45n nf=1 m=(1)
dev_nmos_1 (net11 net9 0 0) g45n1svt w=(120n) l=45n nf=1 m=(1)
dev_pmos_9 (net7 net4 vdd! vdd!) g45p1svt w=(120n) l=45n nf=1 m=(1)
dev_pmos_8 (net4 net4 net7 vdd!) g45p1svt w=(120n) l=45n nf=1 m=(1)
dev_pmos_6 (net6 net4 net2 vdd!) g45p1svt w=(120n) l=45n nf=1 m=(1)
dev_pmos_5 (net8 net5 net10 vdd!) g45p1svt w=(120n) l=45n nf=1 m=(1)
dev_pmos_3 (net2 net4 vdd! vdd!) g45p1svt w=(120n) l=45n nf=1 m=(1)
dev_pmos_11 (net1 net1 vdd! vdd!) g45p1svt w=(120n) l=45n nf=1 m=(1)
dev_pmos_10 (net10 net1 vdd! vdd!) g45p1svt w=(120n) l=45n nf=1 m=(1)
dev_pmos_0 (net11 net12 net10 vdd!) g45p1svt w=(120n) l=45n nf=1 m=(1)
