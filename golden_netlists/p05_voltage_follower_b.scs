// GPDK045 native Cadence adaptation; NOT a performance-matched paper reproduction.
// Missing device sizes/values use recorded defaults; see plan.json and classification CSV.
// Explicit body nets, including deliberately floating bodies, are preserved.
// PDK_BULK_N/PDK_BULK_P, where present, require an external bulk bias.
// Evidence: /projects/2022B4AA1300P/SchematicGeneration/Papers_dataset/consolidated_paper_dataset_final_locked/agnibha_mixed_pdk_20261008/cases/p05_voltage_follower_b
// Original comments below describe the pre-conversion topology:
// original: SchemGen Cadence OA topology netlist for GED only
// original: SCHEMGEN_OA_TARGET=GraphReworkLib/gc_1cecd7e74ea2_cad72a42/schematic
simulator lang=spectre
global 0
include "/linuxeda_new/c2scadence/FOUNDRY/analog/45nm/models/spectre/gpdk045.scs" section=tt

// AgnibhaMixedPDK_20261008/c53_f32c0ae4d7/schematic
dev_nmos_cross_0 (net8 net5 net2 PDK_BULK_N) g45n1svt w=(120n) l=45n nf=1 m=(1)
dev_nmos_6 (net1 net1 net10 PDK_BULK_N) g45n1svt w=(120n) l=45n nf=1 m=(1)
dev_nmos_5 (net9 net7 net10 PDK_BULK_N) g45n1svt w=(120n) l=45n nf=1 m=(1)
dev_nmos_2 (net5 net5 net2 PDK_BULK_N) g45n1svt w=(120n) l=45n nf=1 m=(1)
dev_nmos_1 (net10 net5 net2 PDK_BULK_N) g45n1svt w=(120n) l=45n nf=1 m=(1)
dev_current_3 (net6 net5) isource dc=0 type=dc
dev_pmos_cross_4 (net9 net6 net4 PDK_BULK_P) g45p1svt w=(120n) l=45n nf=1 m=(1)
dev_pmos_9 (net1 net1 net3 PDK_BULK_P) g45p1svt w=(120n) l=45n nf=1 m=(1)
dev_pmos_8 (net3 net6 net4 PDK_BULK_P) g45p1svt w=(120n) l=45n nf=1 m=(1)
dev_pmos_7 (net6 net6 net4 PDK_BULK_P) g45p1svt w=(120n) l=45n nf=1 m=(1)
dev_pmos_10 (net8 net7 net3 PDK_BULK_P) g45p1svt w=(120n) l=45n nf=1 m=(1)
