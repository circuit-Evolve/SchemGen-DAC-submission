// GPDK045 native Cadence adaptation; NOT a performance-matched paper reproduction.
// Missing device sizes/values use recorded defaults; see plan.json and classification CSV.
// Explicit body nets, including deliberately floating bodies, are preserved.
// PDK_BULK_N/PDK_BULK_P, where present, require an external bulk bias.
// Evidence: /projects/2022B4AA1300P/SchematicGeneration/Papers_dataset/consolidated_paper_dataset_final_locked/agnibha_mixed_pdk_20261008/cases/p02_fig1_input_stage
// Original comments below describe the pre-conversion topology:
// original: SchemGen Cadence OA topology netlist for GED only
// original: SCHEMGEN_OA_TARGET=GraphReworkLib/gc_fff8d5ea0a47_79dc90d3/schematic
simulator lang=spectre
global 0
include "/linuxeda_new/c2scadence/FOUNDRY/analog/45nm/models/spectre/gpdk045.scs" section=tt

// AgnibhaMixedPDK_20261008/c06_05e3041e24/schematic
dev_nmos_7 (net2 net9 net8 PDK_BULK_N) g45n1svt w=(120n) l=45n nf=1 m=(1)
dev_nmos_5 (net5 net9 net8 PDK_BULK_N) g45n1svt w=(120n) l=45n nf=1 m=(1)
dev_nmos_1 (net9 net14 net5 PDK_BULK_N) g45n1svt w=(120n) l=45n nf=1 m=(1)
dev_nmos_0 (net1 net14 net2 PDK_BULK_N) g45n1svt w=(120n) l=45n nf=1 m=(1)
dev_pmos_9 (net2 net7 net3 PDK_BULK_P) g45p1svt w=(120n) l=45n nf=1 m=(1)
dev_pmos_8 (net10 net15 net13 PDK_BULK_P) g45p1svt w=(120n) l=45n nf=1 m=(1)
dev_pmos_6 (net5 net6 net3 PDK_BULK_P) g45p1svt w=(120n) l=45n nf=1 m=(1)
dev_pmos_4 (net3 net4 net13 PDK_BULK_P) g45p1svt w=(120n) l=45n nf=1 m=(1)
dev_pmos_3 (net12 net15 net13 PDK_BULK_P) g45p1svt w=(120n) l=45n nf=1 m=(1)
dev_pmos_2 (net1 net11 net12 PDK_BULK_P) g45p1svt w=(120n) l=45n nf=1 m=(1)
dev_pmos_10 (net9 net11 net10 PDK_BULK_P) g45p1svt w=(120n) l=45n nf=1 m=(1)
