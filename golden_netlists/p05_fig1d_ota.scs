// GPDK045 native Cadence adaptation; NOT a performance-matched paper reproduction.
// Missing device sizes/values use recorded defaults; see plan.json and classification CSV.
// Explicit body nets, including deliberately floating bodies, are preserved.
// PDK_BULK_N/PDK_BULK_P, where present, require an external bulk bias.
// Evidence: /projects/2022B4AA1300P/SchematicGeneration/Papers_dataset/consolidated_paper_dataset_final_locked/agnibha_mixed_pdk_20261008/cases/p05_fig1d_ota
// Original comments below describe the pre-conversion topology:
// original: SchemGen Cadence OA topology netlist for GED only
// original: SCHEMGEN_OA_TARGET=GraphReworkLib/gc_753283bc7f18_3bceba14/schematic
simulator lang=spectre
global 0
include "/linuxeda_new/c2scadence/FOUNDRY/analog/45nm/models/spectre/gpdk045.scs" section=tt

// AgnibhaMixedPDK_20261008/c47_38a7ce653f/schematic
dev_nmos_cross_0 (net5 net4 net7 PDK_BULK_N) g45n1svt w=(120n) l=45n nf=1 m=(1)
dev_nmos_9 (net11 net4 net7 PDK_BULK_N) g45n1svt w=(120n) l=45n nf=1 m=(1)
dev_nmos_8 (net4 net4 net7 PDK_BULK_N) g45n1svt w=(120n) l=45n nf=1 m=(1)
dev_nmos_7 (net3 net1 net7 PDK_BULK_N) g45n1svt w=(120n) l=45n nf=1 m=(1)
dev_nmos_6 (net2 net8 net7 PDK_BULK_N) g45n1svt w=(120n) l=45n nf=1 m=(1)
dev_nmos_5 (net1 net1 net7 PDK_BULK_N) g45n1svt w=(120n) l=45n nf=1 m=(1)
dev_nmos_4 (net13 net14 net2 PDK_BULK_N) g45n1svt w=(120n) l=45n nf=1 m=(1)
dev_nmos_3 (net12 net10 net2 PDK_BULK_N) g45n1svt w=(120n) l=45n nf=1 m=(1)
dev_nmos_16 (net6 net9 net8 PDK_BULK_N) g45n1svt w=(120n) l=45n nf=1 m=(1)
dev_nmos_1 (net8 net8 net7 PDK_BULK_N) g45n1svt w=(120n) l=45n nf=1 m=(1)
dev_pmos_cross_11 (net5 net12 net6 PDK_BULK_P) g45p1svt w=(120n) l=45n nf=1 m=(1)
dev_pmos_2 (net12 net12 net6 PDK_BULK_P) g45p1svt w=(120n) l=45n nf=1 m=(1)
dev_pmos_15 (net3 net11 net6 PDK_BULK_P) g45p1svt w=(120n) l=45n nf=1 m=(1)
dev_pmos_14 (net11 net11 net6 PDK_BULK_P) g45p1svt w=(120n) l=45n nf=1 m=(1)
dev_pmos_13 (net13 net13 net6 PDK_BULK_P) g45p1svt w=(120n) l=45n nf=1 m=(1)
dev_pmos_12 (net4 net13 net6 PDK_BULK_P) g45p1svt w=(120n) l=45n nf=1 m=(1)
dev_pmos_10 (net1 net12 net6 PDK_BULK_P) g45p1svt w=(120n) l=45n nf=1 m=(1)
