// GPDK045 native Cadence adaptation; NOT a performance-matched paper reproduction.
// Missing device sizes/values use recorded defaults; see plan.json and classification CSV.
// Explicit body nets, including deliberately floating bodies, are preserved.
// PDK_BULK_N/PDK_BULK_P, where present, require an external bulk bias.
// Evidence: /projects/2022B4AA1300P/SchematicGeneration/Papers_dataset/consolidated_paper_dataset_final_locked/agnibha_mixed_pdk_20261008/cases/p02_two_stage_opamp
// Original comments below describe the pre-conversion topology:
// original: Image-traced topology reference. Explicit D G S B on all seven MOSFETs.
// original: M1/M2 bodies join TAIL; M5/M7 bodies ground; PMOS bodies VDD.
// original: The NGAIN/M7-gate wire crosses the tail without a junction.
simulator lang=spectre
global 0
include "/linuxeda_new/c2scadence/FOUNDRY/analog/45nm/models/spectre/gpdk045.scs" section=tt

// AgnibhaMixedPDK_20261008/c15_d1c4e70807/schematic
M7 (VOUT NGAIN 0 0) g45n1svt w=(120n) l=45n nf=1 m=(1)
M5 (TAIL VREF1 0 0) g45n1svt w=(120n) l=45n nf=1 m=(1)
M2 (NGAIN VINP TAIL TAIL) g45n1svt w=(120n) l=45n nf=1 m=(1)
M1 (DIODE VINM TAIL TAIL) g45n1svt w=(120n) l=45n nf=1 m=(1)
M6 (VOUT VREF2 VDD VDD) g45p1svt w=(120n) l=45n nf=1 m=(1)
M4 (NGAIN DIODE VDD VDD) g45p1svt w=(120n) l=45n nf=1 m=(1)
M3 (DIODE DIODE VDD VDD) g45p1svt w=(120n) l=45n nf=1 m=(1)
Rc (NGAIN NCC) resistor r=900k
C1 (VOUT 0) capacitor c=10p
Cc (NCC VOUT) capacitor c=1p
