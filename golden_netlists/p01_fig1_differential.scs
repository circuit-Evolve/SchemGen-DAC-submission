// GPDK045 native Cadence adaptation; NOT a performance-matched paper reproduction.
// Missing device sizes/values use recorded defaults; see plan.json and classification CSV.
// Explicit body nets, including deliberately floating bodies, are preserved.
// PDK_BULK_N/PDK_BULK_P, where present, require an external bulk bias.
// Evidence: /projects/2022B4AA1300P/SchematicGeneration/Papers_dataset/consolidated_paper_dataset_final_locked/agnibha_mixed_pdk_20261008/cases/p01_fig1_differential
// Original comments below describe the pre-conversion topology:
// original: Manual source-image topology review, 2026-10-02; not a Cadence export.
// original: User confirmed: both ports labelled Out are one electrical net.
// original: M5 gate is visibly wired to its drain/tail. Keep that unusual connection.
// original: All five explicit MOS bodies join their own sources. Order D G S B.
// original: Device model parameters are unspecified; this is not a simulation deck.
// original: Vbias is an external label for TAIL, not a second independent node.
simulator lang=spectre
global 0
include "/linuxeda_new/c2scadence/FOUNDRY/analog/45nm/models/spectre/gpdk045.scs" section=tt

// AgnibhaMixedPDK_20261008/c01_4dff327184/schematic
M2 (OUT OUT VDD VDD) g45p1svt w=(120n) l=45n nf=1 m=(1)
M1 (OUT OUT VDD VDD) g45p1svt w=(120n) l=45n nf=1 m=(1)
M5 (TAIL TAIL 0 0) g45n1svt w=(120n) l=45n nf=1 m=(1)
M4 (OUT IN2 TAIL TAIL) g45n1svt w=(120n) l=45n nf=1 m=(1)
M3 (OUT IN1 TAIL TAIL) g45n1svt w=(120n) l=45n nf=1 m=(1)
