// GPDK045 native Cadence adaptation; NOT a performance-matched paper reproduction.
// Missing device sizes/values use recorded defaults; see plan.json and classification CSV.
// Explicit body nets, including deliberately floating bodies, are preserved.
// PDK_BULK_N/PDK_BULK_P, where present, require an external bulk bias.
// Evidence: /projects/2022B4AA1300P/SchematicGeneration/Papers_dataset/consolidated_paper_dataset_final_locked/agnibha_mixed_pdk_20261008/cases/p05_fig2_2_tunable_ota
// Original comments below describe the pre-conversion topology:
// original: Image-traced topology review: p05_fig2_2_tunable_ota.png
// original: Review: batch1_review_all50_20261002; original image and netlist hashes in scope.json.
// original: MOS terminal order: D G S [B]. Explicit body pins follow the image.
// original: Manually repaired topology only; not a native Cadence export or simulation-qualified deck.
// original: Device sizes, model cards, source/passive values and performance are not validated here.
simulator lang=spectre
global 0
include "/linuxeda_new/c2scadence/FOUNDRY/analog/45nm/models/spectre/gpdk045.scs" section=tt

// AgnibhaMixedPDK_20261008/c48_9a208bf70d/schematic
P8 (OUT D4 VDD VDD) g45p1svt w=(120n) l=45n nf=1 m=(1)
P7 (D4 D4 VDD VDD) g45p1svt w=(120n) l=45n nf=1 m=(1)
P6 (D3 D3 VDD VDD) g45p1svt w=(120n) l=45n nf=1 m=(1)
P5 (NMIR2 D3 VDD VDD) g45p1svt w=(120n) l=45n nf=1 m=(1)
P4 (Z D2 VDD VDD) g45p1svt w=(120n) l=45n nf=1 m=(1)
P3 (D2 D2 VDD VDD) g45p1svt w=(120n) l=45n nf=1 m=(1)
P2 (D1 D1 VDD VDD) g45p1svt w=(120n) l=45n nf=1 m=(1)
P1 (NMIR1 D1 VDD VDD) g45p1svt w=(120n) l=45n nf=1 m=(1)
VINR (VIM 0) vsource dc=0 type=dc
VINL (VIP 0) vsource dc=0 type=dc
VSUP (VDD 0) vsource dc=0 type=dc
N8 (OUT NMIR2 0 0) g45n1svt w=(120n) l=45n nf=1 m=(1)
N7 (NMIR2 NMIR2 0 0) g45n1svt w=(120n) l=45n nf=1 m=(1)
N6 (D4 0 TAIL2 0) g45n1svt w=(120n) l=45n nf=1 m=(1)
N5 (D3 Z TAIL2 0) g45n1svt w=(120n) l=45n nf=1 m=(1)
NBIAS_DOWN (NB NB 0 0) g45n1svt w=(120n) l=45n nf=1 m=(1)
NBIAS_UP (VDD VDD NB 0) g45n1svt w=(120n) l=45n nf=1 m=(1)
N4 (Z NMIR1 0 0) g45n1svt w=(120n) l=45n nf=1 m=(1)
N3 (NMIR1 NMIR1 0 0) g45n1svt w=(120n) l=45n nf=1 m=(1)
N2 (D2 VIM TAIL1 0) g45n1svt w=(120n) l=45n nf=1 m=(1)
N1 (D1 VIP TAIL1 0) g45n1svt w=(120n) l=45n nf=1 m=(1)
