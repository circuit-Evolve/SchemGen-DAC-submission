// SchemGen Cadence OA topology netlist for GED only
// SCHEMGEN_OA_TARGET=GraphReworkLib/gc_1bfae6e8551b_3724761f/schematic
dev_current_8 ( net1 0 ) isource
dev_nmos_0 ( net2 net4 0 ) nmos1v_3
dev_nmos_1 ( net9 net3 net1 ) nmos1v_3
dev_nmos_3 ( net4 net4 0 ) nmos1v_3
dev_nmos_5 ( net6 net7 net1 ) nmos1v_3
dev_pmos_2 ( net6 net8 vdd! ) pmos1v_3
dev_pmos_4 ( net9 net8 vdd! ) pmos1v_3
dev_pmos_6 ( net4 net9 vdd! ) pmos1v_3
dev_pmos_7 ( net2 net6 vdd! ) pmos1v_3
