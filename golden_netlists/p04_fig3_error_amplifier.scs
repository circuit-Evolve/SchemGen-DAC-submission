// GPDK045 native Cadence adaptation; NOT a performance-matched paper reproduction.
// Missing device sizes/values use recorded defaults; see plan.json and classification CSV.
// Explicit body nets, including deliberately floating bodies, are preserved.
// PDK_BULK_N/PDK_BULK_P, where present, require an external bulk bias.
// Evidence: /projects/2022B4AA1300P/SchematicGeneration/Papers_dataset/consolidated_paper_dataset_final_locked/agnibha_mixed_pdk_20261008/cases/p04_fig3_error_amplifier
// Original comments below describe the pre-conversion topology:
// original: Image-traced topology review: p04_fig3_error_amplifier.png
// original: Review: batch1_review_all50_20261002; original image and netlist hashes in scope.json.
// original: MOS terminal order: D G S [B]. Explicit body pins follow the image.
// original: Manually repaired topology only; not a native Cadence export or simulation-qualified deck.
// original: Device sizes, model cards, source/passive values and performance are not validated here.
// original: User: the upper NPD drain crosses the PMOS source rail without joining; M7 gate joins the lower PD-drain vertical wire.
simulator lang=spectre
global 0
include "/linuxeda_new/c2scadence/FOUNDRY/analog/45nm/models/spectre/gpdk045.scs" section=tt

// AgnibhaMixedPDK_20261008/c33_20288a3f92/schematic
PCAP (NC OUT NC NC) g45p1svt w=(120n) l=45n nf=1 m=(1)
PRES (NC VGND NI VDD) g45p1svt w=(120n) l=45n nf=1 m=(1)
M6 (OUT NI VDD VDD) g45p1svt w=(120n) l=45n nf=1 m=(1)
M4 (NI NL VDD VDD) g45p1svt w=(120n) l=45n nf=1 m=(1)
M3 (NL NL VDD VDD) g45p1svt w=(120n) l=45n nf=1 m=(1)
PGATE (NL NPD VDD VDD) g45p1svt w=(120n) l=45n nf=1 m=(1)
M2 (NI VIM TAIL 0) g45n1svt w=(120n) l=45n nf=1 m=(1)
M1 (NL VIP TAIL 0) g45n1svt w=(120n) l=45n nf=1 m=(1)
M7 (OUT VGND VGND VGND) g45n1svt w=(120n) l=45n nf=1 m=(1)
M5 (TAIL VGND VGND VGND) g45n1svt w=(120n) l=45n nf=1 m=(1)
M8 (NB VGND VGND 0) g45n1svt w=(120n) l=45n nf=1 m=(1)
NGATE (VGND PD 0 0) g45n1svt w=(120n) l=45n nf=1 m=(1)
CL (OUT 0) capacitor c=1p
IREF (VDD NB) isource dc=0 type=dc
