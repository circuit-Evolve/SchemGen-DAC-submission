// GPDK045 native Cadence adaptation; NOT a performance-matched paper reproduction.
// Missing device sizes/values use recorded defaults; see plan.json and classification CSV.
// Explicit body nets, including deliberately floating bodies, are preserved.
// PDK_BULK_N/PDK_BULK_P, where present, require an external bulk bias.
// Evidence: /projects/2022B4AA1300P/SchematicGeneration/Papers_dataset/consolidated_paper_dataset_final_locked/agnibha_mixed_pdk_20261008/cases/p02_fig2
// Original comments below describe the pre-conversion topology:
// original: SchemGen Cadence OA topology netlist for GED only
// original: SCHEMGEN_OA_TARGET=GraphReworkLib/gc_38ce6061e629_6c17147f/schematic
simulator lang=spectre
global 0
include "/linuxeda_new/c2scadence/FOUNDRY/analog/45nm/models/spectre/gpdk045.scs" section=tt

// AgnibhaMixedPDK_20261008/c08_33e664f8c3/schematic
dev_capacitor_8 (net6 0) capacitor c=1p
dev_capacitor_10 (net6 net5) capacitor c=1p
dev_nmos_7 (net6 net7 0 0) g45n1svt w=(120n) l=45n nf=1 m=(1)
dev_nmos_5 (net7 net7 0 0) g45n1svt w=(120n) l=45n nf=1 m=(1)
dev_nmos_3 (net8 net4 net2 0) g45n1svt w=(120n) l=45n nf=1 m=(1)
dev_nmos_2 (net1 net3 net2 0) g45n1svt w=(120n) l=45n nf=1 m=(1)
dev_nmos_14 (net8 vdd! net5 0) g45n1svt w=(120n) l=45n nf=1 m=(1)
dev_nmos_1 (net2 net7 0 0) g45n1svt w=(120n) l=45n nf=1 m=(1)
dev_current_0 (vdd! net7) isource dc=0 type=dc
dev_pmos_9 (net1 net1 vdd! vdd!) g45p1svt w=(120n) l=45n nf=1 m=(1)
dev_pmos_6 (net6 net8 vdd! vdd!) g45p1svt w=(120n) l=45n nf=1 m=(1)
dev_pmos_4 (net8 net1 vdd! vdd!) g45p1svt w=(120n) l=45n nf=1 m=(1)
dev_pmos_11 (net5 0 net8 vdd!) g45p1svt w=(120n) l=45n nf=1 m=(1)
