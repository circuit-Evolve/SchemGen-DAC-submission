// SchemGen Cadence OA topology netlist for GED only
// SCHEMGEN_OA_TARGET=GraphReworkLib/gc_e4cefb5ab16b_6963afcf/schematic
dev_capacitor_10 ( net2 net1 ) capacitor
dev_capacitor_13 ( 0 net1 ) capacitor
dev_capacitor_14 ( 0 net1 ) capacitor
dev_capacitor_15 ( net2 net1 ) capacitor
dev_capacitor_7 ( net2 0 ) capacitor
dev_capacitor_9 ( 0 net2 ) capacitor
dev_current_0 ( 0 net1 ) isource
dev_nmos_1 ( net2 net1 0 ) nmos1v_3
dev_pmos_2 ( net2 net1 net3 ) pmos1v_3
dev_resistor2_3 ( net2 net1 ) resistor
