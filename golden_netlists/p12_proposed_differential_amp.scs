// GPDK045 native Cadence adaptation; NOT a performance-matched paper reproduction.
// Missing device sizes/values use recorded defaults; see plan.json and classification CSV.
// Explicit body nets, including deliberately floating bodies, are preserved.
// PDK_BULK_N/PDK_BULK_P, where present, require an external bulk bias.
// Evidence: /projects/2022B4AA1300P/SchematicGeneration/Papers_dataset/consolidated_paper_dataset_final_locked/agnibha_mixed_pdk_20261008/cases/p12_proposed_differential_amp
// Original comments below describe the pre-conversion topology:
// original: Image-traced topology review: p12_proposed_differential_amp.png
// original: Review: batch1_review_all50_20261002; original image and netlist hashes in scope.json.
// original: MOS terminal order: D G S [B]. Explicit body pins follow the image.
// original: Manually repaired topology only; not a native Cadence export or simulation-qualified deck.
// original: Device sizes, model cards, source/passive values and performance are not validated here.
// original: User: follow the common tail wire; do not ground M7 drain based on the nearby GND text.
simulator lang=spectre
global 0
include "/linuxeda_new/c2scadence/FOUNDRY/analog/45nm/models/spectre/gpdk045.scs" section=tt

// AgnibhaMixedPDK_20261008/c69_c62d0555db/schematic
M5 (OUT NL VDD VDD) g45p1svt w=(120n) l=45n nf=1 m=(1)
M4 (NL NL VDD VDD) g45p1svt w=(120n) l=45n nf=1 m=(1)
M7 (TAIL BIAS 0 0) g45n1svt w=(120n) l=45n nf=1 m=(1)
M6 (BIAS BIAS 0 0) g45n1svt w=(120n) l=45n nf=1 m=(1)
M2A (RS INR RR_TOP 0) g45n1svt w=(120n) l=45n nf=1 m=(1)
M3A (OUT INR RS 0) g45n1svt w=(120n) l=45n nf=1 m=(1)
M2 (LS INL RL_TOP 0) g45n1svt w=(120n) l=45n nf=1 m=(1)
M3 (NL INL LS 0) g45n1svt w=(120n) l=45n nf=1 m=(1)
M1A (OUT INR TAIL RR_TOP) g45n1svt w=(120n) l=45n nf=1 m=(1)
M1 (NL INL TAIL RL_TOP) g45n1svt w=(120n) l=45n nf=1 m=(1)
RR (RR_TOP TAIL) resistor r=1K
RL (RL_TOP TAIL) resistor r=1K
IREF (VBIAS BIAS) isource dc=0 type=dc
DC_RIGHT (DC_RIGHT 0) vsource dc=0 type=dc
AC_RIGHT (INR DC_RIGHT) vsource dc=0 type=dc
DC_LEFT (DC_LEFT 0) vsource dc=0 type=dc
AC_LEFT (INL DC_LEFT) vsource dc=0 type=dc
