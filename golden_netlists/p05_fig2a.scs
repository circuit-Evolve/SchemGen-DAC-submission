// GPDK045 native Cadence adaptation; NOT a performance-matched paper reproduction.
// Missing device sizes/values use recorded defaults; see plan.json and classification CSV.
// Explicit body nets, including deliberately floating bodies, are preserved.
// PDK_BULK_N/PDK_BULK_P, where present, require an external bulk bias.
// Evidence: /projects/2022B4AA1300P/SchematicGeneration/Papers_dataset/consolidated_paper_dataset_final_locked/agnibha_mixed_pdk_20261008/cases/p05_fig2a
// Original comments below describe the pre-conversion topology:
// original: SchemGen Cadence OA topology netlist for GED only
// original: SCHEMGEN_OA_TARGET=GraphReworkLib/gc_06713a83e5c2_b9166c01/schematic
simulator lang=spectre
global 0
include "/linuxeda_new/c2scadence/FOUNDRY/analog/45nm/models/spectre/gpdk045.scs" section=tt

// AgnibhaMixedPDK_20261008/c49_40b5685c4e/schematic
dev_capacitor_6 (0 net7) capacitor c=1p
dev_capacitor_18 (net7 net6) capacitor c=1p
dev_nmos_cross_2 (net8 net2 net1 0) g45n1svt w=(120n) l=45n nf=1 m=(1)
dev_nmos_cross_1 (net6 net2 net1 0) g45n1svt w=(120n) l=45n nf=1 m=(1)
dev_nmos_cross_0 (net11 net2 net1 0) g45n1svt w=(120n) l=45n nf=1 m=(1)
dev_nmos_9 (net7 net2 net1 0) g45n1svt w=(120n) l=45n nf=1 m=(1)
dev_nmos_8 (net4 net5 net11 0) g45n1svt w=(120n) l=45n nf=1 m=(1)
dev_nmos_7 (net10 net3 net6 0) g45n1svt w=(120n) l=45n nf=1 m=(1)
dev_nmos_17 (net2 net2 net1 0) g45n1svt w=(120n) l=45n nf=1 m=(1)
dev_nmos_15 (net12 net13 net11 0) g45n1svt w=(120n) l=45n nf=1 m=(1)
dev_nmos_12 (net9 net3 net8 0) g45n1svt w=(120n) l=45n nf=1 m=(1)
dev_current_13 (vdd! net2) isource dc=0 type=dc
dev_pmos_5 (net9 net9 vdd! vdd!) g45p1svt w=(120n) l=45n nf=1 m=(1)
dev_pmos_4 (net4 net4 vdd! vdd!) g45p1svt w=(120n) l=45n nf=1 m=(1)
dev_pmos_3 (net7 net12 vdd! vdd!) g45p1svt w=(120n) l=45n nf=1 m=(1)
dev_pmos_11 (net12 net4 vdd! vdd!) g45p1svt w=(120n) l=45n nf=1 m=(1)
dev_pmos_10 (net10 net9 vdd! vdd!) g45p1svt w=(120n) l=45n nf=1 m=(1)
