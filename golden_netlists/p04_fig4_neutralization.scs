// GPDK045 native Cadence adaptation; NOT a performance-matched paper reproduction.
// Missing device sizes/values use recorded defaults; see plan.json and classification CSV.
// Explicit body nets, including deliberately floating bodies, are preserved.
// PDK_BULK_N/PDK_BULK_P, where present, require an external bulk bias.
// Evidence: /projects/2022B4AA1300P/SchematicGeneration/Papers_dataset/consolidated_paper_dataset_final_locked/agnibha_mixed_pdk_20261008/cases/p04_fig4_neutralization
// Original comments below describe the pre-conversion topology:
// original: Image-traced topology review: p04_fig4_neutralization.png
// original: Review: batch1_review_all50_20261002; original image and netlist hashes in scope.json.
// original: MOS terminal order: D G S [B]. Explicit body pins follow the image.
// original: Manually repaired topology only; not a native Cadence export or simulation-qualified deck.
// original: Device sizes, model cards, source/passive values and performance are not validated here.
simulator lang=spectre
global 0
include "/linuxeda_new/c2scadence/FOUNDRY/analog/45nm/models/spectre/gpdk045.scs" section=tt

// AgnibhaMixedPDK_20261008/c39_b66bdb7f48/schematic
M18 (OUT VB2 PR VDD) g45p1svt w=(120n) l=45n nf=1 m=(1)
M17 (PR NCAS VDD VDD) g45p1svt w=(120n) l=45n nf=1 m=(1)
M15 (NCAS VB2 PL VDD) g45p1svt w=(120n) l=45n nf=1 m=(1)
M14 (PL NCAS VDD VDD) g45p1svt w=(120n) l=45n nf=1 m=(1)
Mo2 (NR VREF OR VDD) g45p1svt w=(120n) l=45n nf=1 m=(1)
Mo1 (NL OUT OL VDD) g45p1svt w=(120n) l=45n nf=1 m=(1)
M16 (OR N1 VDD VDD) g45p1svt w=(120n) l=45n nf=1 m=(1)
M13 (OL N2 VDD VDD) g45p1svt w=(120n) l=45n nf=1 m=(1)
M6 (N2 N2 VDD VDD) g45p1svt w=(120n) l=45n nf=1 m=(1)
M5 (N1 N1 VDD VDD) g45p1svt w=(120n) l=45n nf=1 m=(1)
M4 (TAIL R N2 VDD) g45p1svt w=(120n) l=45n nf=1 m=(1)
M3 (TAIL L N1 VDD) g45p1svt w=(120n) l=45n nf=1 m=(1)
Mi2 (R VIN B VDD) g45p1svt w=(120n) l=45n nf=1 m=(1)
Mi1 (L VIP A VDD) g45p1svt w=(120n) l=45n nf=1 m=(1)
Ms2 (B N1 VDD VDD) g45p1svt w=(120n) l=45n nf=1 m=(1)
Ms1 (A N2 VDD VDD) g45p1svt w=(120n) l=45n nf=1 m=(1)
M11 (BR NR 0 0) g45n1svt w=(120n) l=45n nf=1 m=(1)
M12 (OUT VB1 BR 0) g45n1svt w=(120n) l=45n nf=1 m=(1)
M8 (BL NL 0 0) g45n1svt w=(120n) l=45n nf=1 m=(1)
M9 (NCAS VB1 BL 0) g45n1svt w=(120n) l=45n nf=1 m=(1)
M10 (NR NR 0 0) g45n1svt w=(120n) l=45n nf=1 m=(1)
M7 (NL NL 0 0) g45n1svt w=(120n) l=45n nf=1 m=(1)
CN_MOSCAP (0 R 0 0) g45n1svt w=(120n) l=45n nf=1 m=(1)
Md2 (R L 0 0) g45n1svt w=(120n) l=45n nf=1 m=(1)
Md1 (L L 0 0) g45n1svt w=(120n) l=45n nf=1 m=(1)
R2 (OL OR) resistor r=1K
R1 (A B) resistor r=1K
C2 (OL OR) capacitor c=1p
Ibias (TAIL 0) isource dc=0 type=dc
