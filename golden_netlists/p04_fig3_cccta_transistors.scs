// GPDK045 native Cadence adaptation; NOT a performance-matched paper reproduction.
// Missing device sizes/values use recorded defaults; see plan.json and classification CSV.
// Explicit body nets, including deliberately floating bodies, are preserved.
// PDK_BULK_N/PDK_BULK_P, where present, require an external bulk bias.
// Evidence: /projects/2022B4AA1300P/SchematicGeneration/Papers_dataset/consolidated_paper_dataset_final_locked/agnibha_mixed_pdk_20261008/cases/p04_fig3_cccta_transistors
// Original comments below describe the pre-conversion topology:
// original: Image-traced topology review: p04_fig3_cccta_transistors.png
// original: Review: batch1_review_all50_20261002; original image and netlist hashes in scope.json.
// original: MOS terminal order: D G S [B]. Explicit body pins follow the image.
// original: Manually repaired topology only; not a native Cadence export or simulation-qualified deck.
// original: Device sizes, model cards, source/passive values and performance are not validated here.
simulator lang=spectre
global 0
include "/linuxeda_new/c2scadence/FOUNDRY/analog/45nm/models/spectre/gpdk045.scs" section=tt

// AgnibhaMixedPDK_20261008/c32_494205478e/schematic
M37 (O2M BX VSS VSS) g45n1svt w=(120n) l=45n nf=1 m=(1)
M34b (O2CC BNB VSS VSS) g45n1svt w=(120n) l=45n nf=1 m=(1)
M34a (O2C BNB VSS VSS) g45n1svt w=(120n) l=45n nf=1 m=(1)
M34 (O2 BNB VSS VSS) g45n1svt w=(120n) l=45n nf=1 m=(1)
M36 (BX BX VSS VSS) g45n1svt w=(120n) l=45n nf=1 m=(1)
M35 (BY BNB VSS VSS) g45n1svt w=(120n) l=45n nf=1 m=(1)
M33 (BNB BNB VSS VSS) g45n1svt w=(120n) l=45n nf=1 m=(1)
M25 (BB 0 BTAIL VSS) g45n1svt w=(120n) l=45n nf=1 m=(1)
M24 (BA Z BTAIL VSS) g45n1svt w=(120n) l=45n nf=1 m=(1)
M23a (O1CM AX VSS VSS) g45n1svt w=(120n) l=45n nf=1 m=(1)
M23 (O1M AX VSS VSS) g45n1svt w=(120n) l=45n nf=1 m=(1)
M20a (O1C ANB VSS VSS) g45n1svt w=(120n) l=45n nf=1 m=(1)
M20 (O1 ANB VSS VSS) g45n1svt w=(120n) l=45n nf=1 m=(1)
M22 (AX AX VSS VSS) g45n1svt w=(120n) l=45n nf=1 m=(1)
M21 (AY ANB VSS VSS) g45n1svt w=(120n) l=45n nf=1 m=(1)
M19 (ANB ANB VSS VSS) g45n1svt w=(120n) l=45n nf=1 m=(1)
M11 (AB 0 ATAIL VSS) g45n1svt w=(120n) l=45n nf=1 m=(1)
M10 (AA Z ATAIL VSS) g45n1svt w=(120n) l=45n nf=1 m=(1)
M9d (ZCCC VBB VSS VSS) g45n1svt w=(120n) l=45n nf=1 m=(1)
M9b (ZCC VBB VSS VSS) g45n1svt w=(120n) l=45n nf=1 m=(1)
M9a (ZC VBB VSS VSS) g45n1svt w=(120n) l=45n nf=1 m=(1)
M9 (Z VBB VSS VSS) g45n1svt w=(120n) l=45n nf=1 m=(1)
M8 (X VBB VSS VSS) g45n1svt w=(120n) l=45n nf=1 m=(1)
M7 (TAIL1 VBB VSS VSS) g45n1svt w=(120n) l=45n nf=1 m=(1)
M2 (B X TAIL1 VSS) g45n1svt w=(120n) l=45n nf=1 m=(1)
M1 (A Y TAIL1 VSS) g45n1svt w=(120n) l=45n nf=1 m=(1)
M32 (O2M BY VDD VDD) g45p1svt w=(120n) l=45n nf=1 m=(1)
M29b (O2CC BA VDD VDD) g45p1svt w=(120n) l=45n nf=1 m=(1)
M29a (O2C BA VDD VDD) g45p1svt w=(120n) l=45n nf=1 m=(1)
M29 (O2 BA VDD VDD) g45p1svt w=(120n) l=45n nf=1 m=(1)
M31 (BY BY VDD VDD) g45p1svt w=(120n) l=45n nf=1 m=(1)
M30 (BX BA VDD VDD) g45p1svt w=(120n) l=45n nf=1 m=(1)
M28 (BNB BB VDD VDD) g45p1svt w=(120n) l=45n nf=1 m=(1)
M27 (BB BB VDD VDD) g45p1svt w=(120n) l=45n nf=1 m=(1)
M26 (BA BA VDD VDD) g45p1svt w=(120n) l=45n nf=1 m=(1)
M18a (O1CM AY VDD VDD) g45p1svt w=(120n) l=45n nf=1 m=(1)
M18 (O1M AY VDD VDD) g45p1svt w=(120n) l=45n nf=1 m=(1)
M15a (O1C AA VDD VDD) g45p1svt w=(120n) l=45n nf=1 m=(1)
M15 (O1 AA VDD VDD) g45p1svt w=(120n) l=45n nf=1 m=(1)
M17 (AY AY VDD VDD) g45p1svt w=(120n) l=45n nf=1 m=(1)
M16 (AX AA VDD VDD) g45p1svt w=(120n) l=45n nf=1 m=(1)
M14 (ANB AB VDD VDD) g45p1svt w=(120n) l=45n nf=1 m=(1)
M13 (AB AB VDD VDD) g45p1svt w=(120n) l=45n nf=1 m=(1)
M12 (AA AA VDD VDD) g45p1svt w=(120n) l=45n nf=1 m=(1)
M6c (ZCCC A VDD VDD) g45p1svt w=(120n) l=45n nf=1 m=(1)
M6b (ZCC A VDD VDD) g45p1svt w=(120n) l=45n nf=1 m=(1)
M6a (ZC A VDD VDD) g45p1svt w=(120n) l=45n nf=1 m=(1)
M6 (Z A VDD VDD) g45p1svt w=(120n) l=45n nf=1 m=(1)
M5 (X A VDD VDD) g45p1svt w=(120n) l=45n nf=1 m=(1)
M4 (B B VDD VDD) g45p1svt w=(120n) l=45n nf=1 m=(1)
M3 (A B VDD VDD) g45p1svt w=(120n) l=45n nf=1 m=(1)
IB2 (BTAIL VSS) isource dc=0 type=dc
IB1 (ATAIL VSS) isource dc=0 type=dc
