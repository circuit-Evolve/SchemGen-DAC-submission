// SchemGen Cadence OA topology netlist for GED only
// SCHEMGEN_OA_TARGET=GraphReworkLib/gc_7a1feafbcc3d_18471d24/schematic
I0 ( net2 0 ) isource
dev_capacitor_13 ( 0 net11 ) capacitor
dev_capacitor_14 ( net11 net10 ) capacitor
dev_capacitor_15 ( 0 net4 ) capacitor
dev_nmos_0 ( net8 net10 0 ) nmos1v_3
dev_nmos_2 ( net1 net8 0 ) nmos1v_3
dev_nmos_3 ( net3 net4 net2 ) nmos1v_3
dev_nmos_4 ( net5 net6 net2 ) nmos1v_3
dev_pmos_10 ( net3 net3 vdd! ) pmos1v_3
dev_pmos_11 ( net5 net5 vdd! ) pmos1v_3
dev_pmos_12 ( net1 net3 vdd! ) pmos1v_3
dev_pmos_7 ( net8 net5 vdd! ) pmos1v_3
dev_pmos_9 ( net11 net1 vdd! ) pmos1v_3
dev_resistor2_5 ( net4 0 ) resistor
dev_resistor2_6 ( net4 net11 ) resistor
dev_resistor2_8 ( net10 net8 ) resistor
