// GPDK045 native Cadence adaptation; NOT a performance-matched paper reproduction.
// Missing device sizes/values use recorded defaults; see plan.json and classification CSV.
// Explicit body nets, including deliberately floating bodies, are preserved.
// PDK_BULK_N/PDK_BULK_P, where present, require an external bulk bias.
// Evidence: /projects/2022B4AA1300P/SchematicGeneration/Papers_dataset/consolidated_paper_dataset_final_locked/agnibha_mixed_pdk_20261008/cases/p04_fig5_ldo
// Original comments below describe the pre-conversion topology:
// original: BEST_EFFORT_REPAIRED: closest interpretation of p04_fig5_ldo.png; NOT a certified golden.
// original: User authorized closest matching after being told that crossing wires are ambiguous.
// original: MOS terminal order D G S [B]; dimensions, values and simulation models are not specified.
// original: Native Cadence cell NOT changed. Xschem preview/readback in batch1_review_all50_20261002/ldo_best_effort/.
// original: Best-effort reconstruction authorized by the user: "Just draw the closesst matching". Uncertain source crossings are interpreted below, not independently established.
// original: The long upper black rails are VDD because the left perimeter joins them. The green drain wires bridge across that rail rather than join it.
// original: MPG1 (left green device) drains to GLOW: Mc10/Mc11 gates, Mc12 drain/source of Mc11, Mc19 gate, Mc15 drain, and the Mc9 diode/Mc6-drain/Mc8-gate wire. MPG2 drains to GTOP: Mc12/Mc13 gates, Mc11/Mc5 drains and Mc16 drain. The two green drains are NOT shorted together.
// original: Mc13 drain feeds Mc10 source separately. Mc14 drain feeds Mc8 source separately. Mc10 drain goes to R1 upper end and Mc2 gate (RUP). The short crossing bridge near the resistor upper end does not join RUP to GLOW.
// original: R1 lower end joins Mc1/Mc3 gates and Mc4 drain (RLOW). Mc6/Mc7/Mc4/Mc5/Mc17 share the other lower bias wire NBIAS. The visible bridges keep RUP, RLOW and NBIAS separate.
// original: Mc18 gate follows the drawn loop to VDD; Mc11 gate and source both land on GLOW in this interpretation. These unconventional connections are retained instead of normalizing the design.
// original: All ten NMOS have explicit grounded bodies. Nine PMOS have explicit VDD bodies. Mc14 and the left green transistor MPG1 have only three drawn terminals; no extra body wire is invented for them.
// original: 21 MOS devices and one resistor; no invented sources, capacitors, model cards or sizing. This reconstructs the visible circuit only, not a complete simulation testbench.
simulator lang=spectre
global 0
include "/linuxeda_new/c2scadence/FOUNDRY/analog/45nm/models/spectre/gpdk045.scs" section=tt

// AgnibhaMixedPDK_20261008/c41_5cbeb42c81/schematic
MPG2 (GTOP NPD VDD VDD) g45p1svt w=(120n) l=45n nf=1 m=(1)
MPG1 (GLOW NPD VDD VDD) g45p1svt w=(120n) l=45n nf=1 m=(1)
Mc19 (OUT GLOW VDD VDD) g45p1svt w=(120n) l=45n nf=1 m=(1)
Mc8 (N87 GLOW N148 VDD) g45p1svt w=(120n) l=45n nf=1 m=(1)
Mc11 (GTOP GLOW GLOW VDD) g45p1svt w=(120n) l=45n nf=1 m=(1)
Mc10 (RUP GLOW N1310 VDD) g45p1svt w=(120n) l=45n nf=1 m=(1)
Mc12 (GLOW GTOP VDD VDD) g45p1svt w=(120n) l=45n nf=1 m=(1)
Mc13 (N1310 GTOP VDD VDD) g45p1svt w=(120n) l=45n nf=1 m=(1)
Mc14 (N148 GTOP VDD VDD) g45p1svt w=(120n) l=45n nf=1 m=(1)
Mc9 (GLOW GLOW VDD VDD) g45p1svt w=(120n) l=45n nf=1 m=(1)
Mc18 (NB VDD VDD VDD) g45p1svt w=(120n) l=45n nf=1 m=(1)
Mc3 (N53 RLOW 0 0) g45n1svt w=(120n) l=45n nf=1 m=(1)
Mc5 (GTOP NBIAS N53 0) g45n1svt w=(120n) l=45n nf=1 m=(1)
Mc2 (N42 RUP 0 0) g45n1svt w=(120n) l=45n nf=1 m=(1)
Mc4 (RLOW NBIAS N42 0) g45n1svt w=(120n) l=45n nf=1 m=(1)
Mc7 (N87 NBIAS 0 0) g45n1svt w=(120n) l=45n nf=1 m=(1)
Mc1 (N61 RLOW 0 0) g45n1svt w=(120n) l=45n nf=1 m=(1)
Mc6 (GLOW NBIAS N61 0) g45n1svt w=(120n) l=45n nf=1 m=(1)
Mc15 (GLOW NB 0 0) g45n1svt w=(120n) l=45n nf=1 m=(1)
Mc16 (GTOP NB 0 0) g45n1svt w=(120n) l=45n nf=1 m=(1)
Mc17 (NB NBIAS 0 0) g45n1svt w=(120n) l=45n nf=1 m=(1)
R1 (RUP RLOW) resistor r=1K
