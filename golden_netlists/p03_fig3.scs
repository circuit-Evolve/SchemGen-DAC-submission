// GPDK045 native Cadence adaptation; NOT a performance-matched paper reproduction.
// Missing device sizes/values use recorded defaults; see plan.json and classification CSV.
// Explicit body nets, including deliberately floating bodies, are preserved.
// PDK_BULK_N/PDK_BULK_P, where present, require an external bulk bias.
// Evidence: /projects/2022B4AA1300P/SchematicGeneration/Papers_dataset/consolidated_paper_dataset_final_locked/agnibha_mixed_pdk_20261008/cases/p03_fig3
// Original comments below describe the pre-conversion topology:
// original: SchemGen Cadence OA topology netlist for GED only
// original: SCHEMGEN_OA_TARGET=GraphReworkLib/gc_6938558478b1_4c75fc32/schematic
simulator lang=spectre
global 0
include "/linuxeda_new/c2scadence/FOUNDRY/analog/45nm/models/spectre/gpdk045.scs" section=tt

// AgnibhaMixedPDK_20261008/c22_212395475d/schematic
dev_capacitor_32 (0 net4) capacitor c=1p
dev_capacitor_30 (0 net3) capacitor c=1p
dev_capacitor_17 (0 net7) capacitor c=1p
dev_capacitor_14 (0 net1) capacitor c=1p
dev_nmos_9 (net4 net7 net8 0) g45n1svt w=(120n) l=45n nf=1 m=(1)
dev_nmos_8 (net8 net5 0 0) g45n1svt w=(120n) l=45n nf=1 m=(1)
dev_nmos_7 (net1 net3 net8 0) g45n1svt w=(120n) l=45n nf=1 m=(1)
dev_nmos_6 (net4 net1 0 0) g45n1svt w=(120n) l=45n nf=1 m=(1)
dev_nmos_5 (net1 net4 0 0) g45n1svt w=(120n) l=45n nf=1 m=(1)
dev_nmos_4 (net7 net1 net2 0) g45n1svt w=(120n) l=45n nf=1 m=(1)
dev_nmos_36 (net1 net6 net4 0) g45n1svt w=(120n) l=45n nf=1 m=(1)
dev_nmos_3 (net7 net3 0 0) g45n1svt w=(120n) l=45n nf=1 m=(1)
dev_nmos_26 (net3 net6 net7 0) g45n1svt w=(120n) l=45n nf=1 m=(1)
dev_nmos_2 (net3 net7 0 0) g45n1svt w=(120n) l=45n nf=1 m=(1)
dev_nmos_1 (net3 net4 net2 0) g45n1svt w=(120n) l=45n nf=1 m=(1)
dev_nmos_0 (net2 net5 0 0) g45n1svt w=(120n) l=45n nf=1 m=(1)
dev_pmos_13 (net1 net9 vdd! vdd!) g45p1svt w=(120n) l=45n nf=1 m=(1)
dev_pmos_12 (net7 net9 vdd! vdd!) g45p1svt w=(120n) l=45n nf=1 m=(1)
dev_pmos_11 (net3 net9 vdd! vdd!) g45p1svt w=(120n) l=45n nf=1 m=(1)
dev_pmos_10 (net4 net9 vdd! vdd!) g45p1svt w=(120n) l=45n nf=1 m=(1)
