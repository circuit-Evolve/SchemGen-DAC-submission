// GPDK045 native Cadence adaptation; NOT a performance-matched paper reproduction.
// Missing device sizes/values use recorded defaults; see plan.json and classification CSV.
// Explicit body nets, including deliberately floating bodies, are preserved.
// PDK_BULK_N/PDK_BULK_P, where present, require an external bulk bias.
// Evidence: /projects/2022B4AA1300P/SchematicGeneration/Papers_dataset/consolidated_paper_dataset_final_locked/agnibha_mixed_pdk_20261008/cases/p07_fig9_cmfb
// Original comments below describe the pre-conversion topology:
// original: SchemGen Cadence OA topology netlist for GED only
// original: SCHEMGEN_OA_TARGET=GraphReworkLib/gc_7dce3839dcd7_68d477ae/schematic
simulator lang=spectre
global 0
include "/linuxeda_new/c2scadence/FOUNDRY/analog/45nm/models/spectre/gpdk045.scs" section=tt

// AgnibhaMixedPDK_20261008/c63_7067d277f6/schematic
dev_capacitor_2 (net1 net11) capacitor c=1p
dev_capacitor_1 (net2 net1) capacitor c=1p
dev_nmos_9 (net8 net7 net9 0) g45n1svt w=(120n) l=45n nf=1 m=(1)
dev_nmos_8 (net6 net7 net5 0) g45n1svt w=(120n) l=45n nf=1 m=(1)
dev_nmos_5 (net5 net6 0 0) g45n1svt w=(120n) l=45n nf=1 m=(1)
dev_nmos_4 (net9 net8 0 0) g45n1svt w=(120n) l=45n nf=1 m=(1)
dev_pmos_6 (net6 net1 net10 PDK_BULK_P) g45p1svt w=(120n) l=45n nf=1 m=(1)
dev_pmos_12 (net10 net4 net3 PDK_BULK_P) g45p1svt w=(120n) l=45n nf=1 m=(1)
dev_pmos_10 (net8 net12 net10 PDK_BULK_P) g45p1svt w=(120n) l=45n nf=1 m=(1)
dev_resistor2_3 (net1 net2) resistor r=1K
dev_resistor2_0 (net11 net1) resistor r=1K
