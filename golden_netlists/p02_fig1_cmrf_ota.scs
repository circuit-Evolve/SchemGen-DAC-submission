// GPDK045 native Cadence adaptation; NOT a performance-matched paper reproduction.
// Missing device sizes/values use recorded defaults; see plan.json and classification CSV.
// Explicit body nets, including deliberately floating bodies, are preserved.
// PDK_BULK_N/PDK_BULK_P, where present, require an external bulk bias.
// Evidence: /projects/2022B4AA1300P/SchematicGeneration/Papers_dataset/consolidated_paper_dataset_final_locked/agnibha_mixed_pdk_20261008/cases/p02_fig1_cmrf_ota
// Original comments below describe the pre-conversion topology:
// original: Image-reviewed topology netlist; not a simulation deck.
// original: Source image: p02_fig1_cmrf_ota.png
// original: SOURCE_OA_TARGET=GraphReworkLib/gc_a9d30f8bbd52_47806748/schematic
// original: Source OA cell is provenance only; its schematic was NOT modified.
// original: Review record: ../../batch1_review_saved17_20261001/review_record.txt
// original: MOS pin order D G S [B]; BJT C B E; current-source PLUS MINUS.
// original: Rebuilt the 31-MOS, four-resistor and one-capacitor connections from the image. Restored the two input gate buses, crossed recycling branches, resistor-isolated gates and output feedback branch. Grounded the eight-device bottom source rail as instructed. Kept repeated C1/C2 labels on the left and right as separate nets; retained the visible left-C1-to-M20-gate wire. M19 gate remains grounded as drawn. No explicit body terminals are drawn.
simulator lang=spectre
global 0
include "/linuxeda_new/c2scadence/FOUNDRY/analog/45nm/models/spectre/gpdk045.scs" section=tt

// AgnibhaMixedPDK_20261008/c04_3a5696ba32/schematic
M20 (CFB C1 VCAS VDD) g45p1svt w=(120n) l=45n nf=1 m=(1)
M10 (OUT VB2 PR VDD) g45p1svt w=(120n) l=45n nf=1 m=(1)
M9 (VCAS VB2 PL VDD) g45p1svt w=(120n) l=45n nf=1 m=(1)
M12 (PR VCAS VDD VDD) g45p1svt w=(120n) l=45n nf=1 m=(1)
M11 (PL VCAS VDD VDD) g45p1svt w=(120n) l=45n nf=1 m=(1)
M2c (R3 VINN TAIL VDD) g45p1svt w=(120n) l=45n nf=1 m=(1)
M2b (R2 VINN TAIL VDD) g45p1svt w=(120n) l=45n nf=1 m=(1)
M2a (R1 VINN TAIL VDD) g45p1svt w=(120n) l=45n nf=1 m=(1)
M1c (L3 VINP TAIL VDD) g45p1svt w=(120n) l=45n nf=1 m=(1)
M1b (L2 VINP TAIL VDD) g45p1svt w=(120n) l=45n nf=1 m=(1)
M1a (L1 VINP TAIL VDD) g45p1svt w=(120n) l=45n nf=1 m=(1)
M0 (TAIL VB1 VDD VDD) g45p1svt w=(120n) l=45n nf=1 m=(1)
M19 (NGATE 0 CFB 0) g45n1svt w=(120n) l=45n nf=1 m=(1)
M6 (RIGHT_C2 CFB 0 0) g45n1svt w=(120n) l=45n nf=1 m=(1)
M5 (RIGHT_C1 NGATE 0 0) g45n1svt w=(120n) l=45n nf=1 m=(1)
M8 (OUT VCAS RIGHT_C2 0) g45n1svt w=(120n) l=45n nf=1 m=(1)
M7 (CFB VCAS RIGHT_C1 0) g45n1svt w=(120n) l=45n nf=1 m=(1)
M4a (C1 RCROSS 0 0) g45n1svt w=(120n) l=45n nf=1 m=(1)
M4b (RCROSS RBG 0 0) g45n1svt w=(120n) l=45n nf=1 m=(1)
M4c (RCROSS RCG 0 0) g45n1svt w=(120n) l=45n nf=1 m=(1)
M4d (RDIODE RDIODE 0 0) g45n1svt w=(120n) l=45n nf=1 m=(1)
M3d (LDIODE LDIODE 0 0) g45n1svt w=(120n) l=45n nf=1 m=(1)
M3c (LCROSS LCG 0 0) g45n1svt w=(120n) l=45n nf=1 m=(1)
M3b (LCROSS LBG 0 0) g45n1svt w=(120n) l=45n nf=1 m=(1)
M3a (C2 LCROSS 0 0) g45n1svt w=(120n) l=45n nf=1 m=(1)
M18 (R3 VINP RDIODE 0) g45n1svt w=(120n) l=45n nf=1 m=(1)
M16 (R2 VINP LCROSS 0) g45n1svt w=(120n) l=45n nf=1 m=(1)
M14 (R1 VINP C1 0) g45n1svt w=(120n) l=45n nf=1 m=(1)
M17 (L3 VINN LDIODE 0) g45n1svt w=(120n) l=45n nf=1 m=(1)
M15 (L2 VINN RCROSS 0) g45n1svt w=(120n) l=45n nf=1 m=(1)
M13 (L1 VINN C2 0) g45n1svt w=(120n) l=45n nf=1 m=(1)
RR2 (RBG RCROSS) resistor r=1K
RR1 (RDIODE RCG) resistor r=1K
RL2 (LCG LDIODE) resistor r=1K
RL1 (LCROSS LBG) resistor r=1K
Cload (OUT 0) capacitor c=1p
