// GPDK045 native Cadence adaptation; NOT a performance-matched paper reproduction.
// Missing device sizes/values use recorded defaults; see plan.json and classification CSV.
// Explicit body nets, including deliberately floating bodies, are preserved.
// PDK_BULK_N/PDK_BULK_P, where present, require an external bulk bias.
// Evidence: /projects/2022B4AA1300P/SchematicGeneration/Papers_dataset/consolidated_paper_dataset_final_locked/agnibha_mixed_pdk_20261008/cases/p06_fig1_target_op_amp
// Original comments below describe the pre-conversion topology:
// original: SchemGen Cadence OA topology netlist for GED only
// original: SCHEMGEN_OA_TARGET=GraphReworkLib/gc_d7549d8cc716_9031db2d/schematic
simulator lang=spectre
global 0
include "/linuxeda_new/c2scadence/FOUNDRY/analog/45nm/models/spectre/gpdk045.scs" section=tt

// AgnibhaMixedPDK_20261008/c54_36eabc0231/schematic
dev_capacitor_9 (net4 net3) capacitor c=1p
dev_nmos_cross_0 (net5 net9 net8 PDK_BULK_N) g45n1svt w=(120n) l=45n nf=1 m=(1)
dev_nmos_6 (net4 net9 net8 PDK_BULK_N) g45n1svt w=(120n) l=45n nf=1 m=(1)
dev_nmos_5 (net6 net7 net5 PDK_BULK_N) g45n1svt w=(120n) l=45n nf=1 m=(1)
dev_nmos_3 (net1 net2 net5 PDK_BULK_N) g45n1svt w=(120n) l=45n nf=1 m=(1)
dev_nmos_2 (net9 net9 net8 PDK_BULK_N) g45n1svt w=(120n) l=45n nf=1 m=(1)
dev_current_4 (net10 net9) isource dc=0 type=dc
dev_pmos_8 (net1 net1 net10 PDK_BULK_P) g45p1svt w=(120n) l=45n nf=1 m=(1)
dev_pmos_7 (net6 net1 net10 PDK_BULK_P) g45p1svt w=(120n) l=45n nf=1 m=(1)
dev_pmos_10 (net4 net6 net10 PDK_BULK_P) g45p1svt w=(120n) l=45n nf=1 m=(1)
dev_resistor2_1 (net3 net6) resistor r=1K
