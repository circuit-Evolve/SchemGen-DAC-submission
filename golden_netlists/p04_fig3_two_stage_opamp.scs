// GPDK045 native Cadence adaptation; NOT a performance-matched paper reproduction.
// Missing device sizes/values use recorded defaults; see plan.json and classification CSV.
// Explicit body nets, including deliberately floating bodies, are preserved.
// PDK_BULK_N/PDK_BULK_P, where present, require an external bulk bias.
// Evidence: /projects/2022B4AA1300P/SchematicGeneration/Papers_dataset/consolidated_paper_dataset_final_locked/agnibha_mixed_pdk_20261008/cases/p04_fig3_two_stage_opamp
// Original comments below describe the pre-conversion topology:
// original: Image-traced topology reference. All MOS symbols have D G S only.
// original: Current flows from VDD DOWN to BIAS, following the Iref arrow.
// original: VSS is the separate bottom supply rail; CL returns to ground as drawn.
simulator lang=spectre
global 0
include "/linuxeda_new/c2scadence/FOUNDRY/analog/45nm/models/spectre/gpdk045.scs" section=tt

// AgnibhaMixedPDK_20261008/c34_03a8c6c62e/schematic
M8 (BIAS BIAS VSS VSS) g45n1svt w=(120n) l=45n nf=1 m=(1)
M7 (VOUT BIAS VSS VSS) g45n1svt w=(120n) l=45n nf=1 m=(1)
M5 (TAIL BIAS VSS VSS) g45n1svt w=(120n) l=45n nf=1 m=(1)
M2 (GAIN VINP TAIL VSS) g45n1svt w=(120n) l=45n nf=1 m=(1)
M1 (DIODE VINM TAIL VSS) g45n1svt w=(120n) l=45n nf=1 m=(1)
M6 (VOUT GAIN VDD VDD) g45p1svt w=(120n) l=45n nf=1 m=(1)
M4 (GAIN DIODE VDD VDD) g45p1svt w=(120n) l=45n nf=1 m=(1)
M3 (DIODE DIODE VDD VDD) g45p1svt w=(120n) l=45n nf=1 m=(1)
CL (VOUT 0) capacitor c=1p
Cc (GAIN VOUT) capacitor c=1p
Iref (VDD BIAS) isource dc=0 type=dc
