// GPDK045 native Cadence adaptation; NOT a performance-matched paper reproduction.
// Missing device sizes/values use recorded defaults; see plan.json and classification CSV.
// Explicit body nets, including deliberately floating bodies, are preserved.
// PDK_BULK_N/PDK_BULK_P, where present, require an external bulk bias.
// Evidence: /projects/2022B4AA1300P/SchematicGeneration/Papers_dataset/consolidated_paper_dataset_final_locked/agnibha_mixed_pdk_20261008/cases/p06_fig7a_rectifier_lpf
// Original comments below describe the pre-conversion topology:
// original: SchemGen Cadence OA topology netlist for GED only
// original: SCHEMGEN_OA_TARGET=GraphReworkLib/gc_3fbfa1952146_7d9108a5/schematic
simulator lang=spectre
global 0
include "/linuxeda_new/c2scadence/FOUNDRY/analog/45nm/models/spectre/gpdk045.scs" section=tt

// AgnibhaMixedPDK_20261008/c59_c92737c651/schematic
dev_capacitor_13 (0 net8) capacitor c=1p
dev_nmos_9 (net5 net5 net13 0) g45n1svt w=(120n) l=45n nf=1 m=(1)
dev_nmos_7 (net13 net13 0 0) g45n1svt w=(120n) l=45n nf=1 m=(1)
dev_nmos_4 (net3 net5 net4 0) g45n1svt w=(120n) l=45n nf=1 m=(1)
dev_nmos_3 (net2 net2 net1 0) g45n1svt w=(120n) l=45n nf=1 m=(1)
dev_nmos_10 (net4 net13 0 0) g45n1svt w=(120n) l=45n nf=1 m=(1)
dev_nmos_1 (net8 net8 0 0) g45n1svt w=(120n) l=45n nf=1 m=(1)
dev_pmos_8 (net5 net5 net1 PDK_BULK_P) g45p1svt w=(120n) l=45n nf=1 m=(1)
dev_pmos_6 (net6 net12 net9 PDK_BULK_P) g45p1svt w=(120n) l=45n nf=1 m=(1)
dev_pmos_5 (net2 net2 net11 PDK_BULK_P) g45p1svt w=(120n) l=45n nf=1 m=(1)
dev_pmos_2 (net5 net2 net10 PDK_BULK_P) g45p1svt w=(120n) l=45n nf=1 m=(1)
dev_pmos_16 (net12 net12 net9 PDK_BULK_P) g45p1svt w=(120n) l=45n nf=1 m=(1)
dev_pmos_14 (net11 net11 net7 PDK_BULK_P) g45p1svt w=(120n) l=45n nf=1 m=(1)
dev_pmos_12 (net3 net3 net12 PDK_BULK_P) g45p1svt w=(120n) l=45n nf=1 m=(1)
dev_pmos_11 (net10 net11 net7 PDK_BULK_P) g45p1svt w=(120n) l=45n nf=1 m=(1)
dev_pmos_0 (net8 net3 net6 PDK_BULK_P) g45p1svt w=(120n) l=45n nf=1 m=(1)
