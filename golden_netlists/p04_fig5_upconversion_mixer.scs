// GPDK045 native Cadence adaptation; NOT a performance-matched paper reproduction.
// Missing device sizes/values use recorded defaults; see plan.json and classification CSV.
// Explicit body nets, including deliberately floating bodies, are preserved.
// PDK_BULK_N/PDK_BULK_P, where present, require an external bulk bias.
// Evidence: /projects/2022B4AA1300P/SchematicGeneration/Papers_dataset/consolidated_paper_dataset_final_locked/agnibha_mixed_pdk_20261008/cases/p04_fig5_upconversion_mixer
// Original comments below describe the pre-conversion topology:
// original: Image-traced topology review: p04_fig5_upconversion_mixer.png
// original: Review: batch1_review_all50_20261002; original image and netlist hashes in scope.json.
// original: MOS terminal order: D G S [B]. Explicit body pins follow the image.
// original: Manually repaired topology only; not a native Cadence export or simulation-qualified deck.
// original: Device sizes, model cards, source/passive values and performance are not validated here.
// original: User: the curved differential-port marks are connecting wires; join each +/- pair.
simulator lang=spectre
global 0
include "/linuxeda_new/c2scadence/FOUNDRY/analog/45nm/models/spectre/gpdk045.scs" section=tt

// AgnibhaMixedPDK_20261008/c44_3cf3309fc9/schematic
C8 (RF_SOURCE RF_OUT) capacitor c=1p
C7 (RF_SOURCE RF_OUT) capacitor c=1p
C4 (VCC RF2) capacitor c=1p
C3 (VCC RF1) capacitor c=1p
C6 (LO LG2) capacitor c=1p
C5 (LO LG1) capacitor c=1p
C2 (IF IG2) capacitor c=1p
C1 (IF IG1) capacitor c=1p
VIF (IF 0) vsource dc=0 type=dc
VLO (LO 0) vsource dc=0 type=dc
R7 (VB4 BG2) resistor r=1K
R6 (VB4 BG1) resistor r=1K
R5 (VB2 LG2) resistor r=1K
R4 (VB2 LG1) resistor r=1K
R1 (T1 T2) resistor r=1K
R3 (VB1 IG2) resistor r=1K
R2 (VB1 IG1) resistor r=1K
M12 (T2 VB3 VCC VCC) g45p1svt w=(120n) l=45n nf=1 m=(1)
M11 (T1 VB3 VCC VCC) g45p1svt w=(120n) l=45n nf=1 m=(1)
M5P (NB2 IG2 VCC VCC) g45p1svt w=(120n) l=45n nf=1 m=(1)
M1 (NB1 IG1 VCC VCC) g45p1svt w=(120n) l=45n nf=1 m=(1)
M16 (RF_SOURCE BG2 0 0) g45n1svt w=(120n) l=45n nf=1 m=(1)
M15 (RF_SOURCE BG1 0 0) g45n1svt w=(120n) l=45n nf=1 m=(1)
M14 (VCC RF2 RF_SOURCE 0) g45n1svt w=(120n) l=45n nf=1 m=(1)
M13 (VCC RF1 RF_SOURCE 0) g45n1svt w=(120n) l=45n nf=1 m=(1)
M10 (RF2 LG1 T2 0) g45n1svt w=(120n) l=45n nf=1 m=(1)
M9 (RF1 LG2 T2 0) g45n1svt w=(120n) l=45n nf=1 m=(1)
M8 (RF2 LG2 T1 0) g45n1svt w=(120n) l=45n nf=1 m=(1)
M7 (RF1 LG1 T1 0) g45n1svt w=(120n) l=45n nf=1 m=(1)
M6 (T2 NB2 0 0) g45n1svt w=(120n) l=45n nf=1 m=(1)
M5N (NB2 NB2 0 0) g45n1svt w=(120n) l=45n nf=1 m=(1)
M3 (T1 NB1 0 0) g45n1svt w=(120n) l=45n nf=1 m=(1)
M2 (NB1 NB1 0 0) g45n1svt w=(120n) l=45n nf=1 m=(1)
L2 (VCC RF2) inductor l=1n
L1 (VCC RF1) inductor l=1n
