// SchemGen Cadence OA topology netlist for GED only
// SCHEMGEN_OA_TARGET=GraphReworkLib/gc_e59764c10940_cac40098/schematic
PM1 ( net1 pin net2 ) pmos1v_3
PM5 ( net13 pin net2 ) pmos1v_3
PM6 ( net14 pin net2 ) pmos1v_3
dev_capacitor_0 ( 0 net2 ) capacitor
dev_capacitor_2 ( 0 net3 ) capacitor
dev_inductor_1 ( net3 net9 ) inductor
dev_inductor_3 ( net3 net13 ) inductor
dev_inductor_5 ( net3 net14 ) inductor
dev_inductor_6 ( net3 net1 ) inductor
dev_pmos_bulk_12 ( 0 net7 net1 ) pmos1v_3
dev_pmos_bulk_13 ( 0 pin net13 ) pmos1v_3
dev_pmos_bulk_14 ( 0 pin net9 ) pmos1v_3
dev_pmos_bulk_15 ( 0 pin net14 ) pmos1v_3
dev_pmos_bulk_21 ( net9 pin net2 ) pmos1v_3
