// GPDK045 native Cadence adaptation; NOT a performance-matched paper reproduction.
// Missing device sizes/values use recorded defaults; see plan.json and classification CSV.
// Explicit body nets, including deliberately floating bodies, are preserved.
// PDK_BULK_N/PDK_BULK_P, where present, require an external bulk bias.
// Evidence: /projects/2022B4AA1300P/SchematicGeneration/Papers_dataset/consolidated_paper_dataset_final_locked/agnibha_mixed_pdk_20261008/cases/p03_fig5_proposed_ota
// Original comments below describe the pre-conversion topology:
// original: Image-reviewed topology netlist; not a simulation deck.
// original: Source image: p03_fig5_proposed_ota.png
// original: SOURCE_OA_TARGET=GraphReworkLib/gc_f2be39189da1_74d33e92/schematic
// original: Source OA cell is provenance only; its schematic was NOT modified.
// original: Review record: ../../batch1_review_saved17_20261001/review_record.txt
// original: MOS pin order D G S [B]; BJT C B E; current-source PLUS MINUS.
// original: Added VDD body pins to M3/M4/M9/M11. All 16 MOSFETs are now explicitly four-terminal. Preserved the existing shared In input, V1 bias link, crossed enhancement gates, output stages and compensation capacitor.
simulator lang=spectre
global 0
include "/linuxeda_new/c2scadence/FOUNDRY/analog/45nm/models/spectre/gpdk045.scs" section=tt

// AgnibhaMixedPDK_20261008/c26_b6ae21e9c6/schematic
M12 (OUT N4 0 0) g45n1svt w=(120n) l=45n nf=1 m=(1)
M10 (N4 BIAS 0 0) g45n1svt w=(120n) l=45n nf=1 m=(1)
M8 (N3 NL 0 0) g45n1svt w=(120n) l=45n nf=1 m=(1)
M6 (BIAS BIAS 0 0) g45n1svt w=(120n) l=45n nf=1 m=(1)
M5 (TAIL BIAS 0 0) g45n1svt w=(120n) l=45n nf=1 m=(1)
MA4 (NB V2 0 0) g45n1svt w=(120n) l=45n nf=1 m=(1)
MA3 (NA V2 0 0) g45n1svt w=(120n) l=45n nf=1 m=(1)
MA2 (NR NL NB 0) g45n1svt w=(120n) l=45n nf=1 m=(1)
MA1 (NL NR NA 0) g45n1svt w=(120n) l=45n nf=1 m=(1)
M2 (NR IN TAIL 0) g45n1svt w=(120n) l=45n nf=1 m=(1)
M1 (NL IN TAIL 0) g45n1svt w=(120n) l=45n nf=1 m=(1)
M11 (OUT N4 VDD VDD) g45p1svt w=(120n) l=45n nf=1 m=(1)
M9 (N4 N3 VDD VDD) g45p1svt w=(120n) l=45n nf=1 m=(1)
M7 (N3 NL VDD VDD) g45p1svt w=(120n) l=45n nf=1 m=(1)
M4 (NR NL VDD VDD) g45p1svt w=(120n) l=45n nf=1 m=(1)
M3 (NL NL VDD VDD) g45p1svt w=(120n) l=45n nf=1 m=(1)
CL (OUT 0) capacitor c=1p
CC (N3 N4) capacitor c=1p
Ibias (VDD BIAS) isource dc=0 type=dc
