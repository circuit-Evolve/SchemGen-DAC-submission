// GPDK045 native Cadence adaptation; NOT a performance-matched paper reproduction.
// Missing device sizes/values use recorded defaults; see plan.json and classification CSV.
// Explicit body nets, including deliberately floating bodies, are preserved.
// PDK_BULK_N/PDK_BULK_P, where present, require an external bulk bias.
// Evidence: /projects/2022B4AA1300P/SchematicGeneration/Papers_dataset/consolidated_paper_dataset_final_locked/agnibha_mixed_pdk_20261008/cases/p02_vdta_cmos_circuit
// Original comments below describe the pre-conversion topology:
// original: SchemGen Cadence OA topology netlist for GED only
// original: SCHEMGEN_OA_TARGET=GraphReworkLib/gc_d21da2eb542a_7aaa0949/schematic
simulator lang=spectre
global 0
include "/linuxeda_new/c2scadence/FOUNDRY/analog/45nm/models/spectre/gpdk045.scs" section=tt

// AgnibhaMixedPDK_20261008/c16_ce4bb6b412/schematic
dev_nmos_5 (net10 net1 net6 0) g45n1svt w=(120n) l=45n nf=1 m=(1)
dev_nmos_2 (net11 0 net9 0) g45n1svt w=(120n) l=45n nf=1 m=(1)
dev_nmos_1 (net8 net10 net9 0) g45n1svt w=(120n) l=45n nf=1 m=(1)
dev_nmos_0 (0 net7 net6 0) g45n1svt w=(120n) l=45n nf=1 m=(1)
dev_current_9 (net5 net4) isource dc=0 type=dc
dev_current_6 (net5 net2) isource dc=0 type=dc
dev_current_4 (net6 net3) isource dc=0 type=dc
dev_current_3 (net9 net3) isource dc=0 type=dc
dev_pmos_8 (0 net7 net4 PDK_BULK_P) g45p1svt w=(120n) l=45n nf=1 m=(1)
dev_pmos_7 (net8 net10 net2 PDK_BULK_P) g45p1svt w=(120n) l=45n nf=1 m=(1)
dev_pmos_11 (net10 net1 net4 PDK_BULK_P) g45p1svt w=(120n) l=45n nf=1 m=(1)
dev_pmos_10 (net11 0 net2 PDK_BULK_P) g45p1svt w=(120n) l=45n nf=1 m=(1)
